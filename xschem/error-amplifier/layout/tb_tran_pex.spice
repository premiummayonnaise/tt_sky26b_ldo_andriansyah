* PEX transient testbench (parasitic-extracted error-amplifier)
** sch_path: /foss/designs/2026/tt_sky26b_ldo_andriansyah/xschem/error-amplifier/testbench/tb_tran_pex.sch
**.subckt tb_tran_pex
V5 VDD VSS 1.8
V7 VSS GND 0
V1 VP VSS PULSE(0 1.8 1u 1n 1n 5u 10u)
x1 VDD OUT VP IBIAS OUT VSS error-amplifier_flat
x3 VDD IBIAS VDD VREF VSS bias-network

**** begin user architecture code

.control
  .temp 27
  op
  tran 100n 20u
  plot OUT VP
.endc

** opencircuitdesign pdks install
.lib /foss/pdks/sky130A/libs.tech/combined/sky130.lib.spice tt

** PEX (parasitic) subcircuit for the error amplifier
.include /foss/designs/2026/tt_sky26b_ldo_andriansyah/xschem/error-amplifier/layout/error-amplifier_flat.spice

**** end user architecture code
**.ends

* expanding   symbol:  /foss/designs/2026/tt_sky26b_ldo_andriansyah/xschem/bias-net/schematics/bias-network.sym # of pins=5
** sym_path: /foss/designs/2026/tt_sky26b_ldo_andriansyah/xschem/bias-net/schematics/bias-network.sym
** sch_path: /foss/designs/2026/tt_sky26b_ldo_andriansyah/xschem/bias-net/schematics/bias-network.sch
.subckt bias-network VDD IBIAS1 IBIAS2 VREF VSS
*.iopin VDD
*.iopin VSS
*.opin IBIAS1
*.opin IBIAS2
*.opin VREF
XM2 VREF VREF VSS VSS sky130_fd_pr__nfet_01v8 L=2 W=3 nf=4 ad='int((nf+1)/2) * W/nf * 0.29' as='int((nf+2)/2) * W/nf * 0.29' pd='2*int((nf+1)/2) * (W/nf + 0.29)'
+ ps='2*int((nf+2)/2) * (W/nf + 0.29)' nrd='0.29 / W' nrs='0.29 / W' sa=0 sb=0 sd=0 mult=2 m=2
XR1 VREF net1 VSS sky130_fd_pr__res_xhigh_po_0p69 L=6.9 mult=1 m=1
XR2 net2 net1 VSS sky130_fd_pr__res_xhigh_po_0p69 L=6.9 mult=1 m=1
XR3 net2 net3 VSS sky130_fd_pr__res_xhigh_po_0p69 L=6.9 mult=1 m=1
XR4 net4 net3 VSS sky130_fd_pr__res_xhigh_po_0p69 L=6.9 mult=1 m=1
XR5 net4 net5 VSS sky130_fd_pr__res_xhigh_po_0p69 L=6.9 mult=1 m=1
XR6 net9 net10 VSS sky130_fd_pr__res_xhigh_po_0p69 L=6.9 mult=1 m=1
XR7 net9 net8 VSS sky130_fd_pr__res_xhigh_po_0p69 L=6.9 mult=1 m=1
XR8 net7 net8 VSS sky130_fd_pr__res_xhigh_po_0p69 L=6.9 mult=1 m=1
XR9 net7 net6 VSS sky130_fd_pr__res_xhigh_po_0p69 L=6.9 mult=1 m=1
XR10 net5 net6 VSS sky130_fd_pr__res_xhigh_po_0p69 L=6.9 mult=1 m=1
XM1 IBIAS1 VREF VSS VSS sky130_fd_pr__nfet_01v8 L=2 W=3 nf=4 ad='int((nf+1)/2) * W/nf * 0.29' as='int((nf+2)/2) * W/nf * 0.29' pd='2*int((nf+1)/2) * (W/nf + 0.29)'
+ ps='2*int((nf+2)/2) * (W/nf + 0.29)' nrd='0.29 / W' nrs='0.29 / W' sa=0 sb=0 sd=0 mult=2 m=2
XM3 IBIAS2 VREF VSS VSS sky130_fd_pr__nfet_01v8 L=2 W=3 nf=4 ad='int((nf+1)/2) * W/nf * 0.29' as='int((nf+2)/2) * W/nf * 0.29' pd='2*int((nf+1)/2) * (W/nf + 0.29)'
+ ps='2*int((nf+2)/2) * (W/nf + 0.29)' nrd='0.29 / W' nrs='0.29 / W' sa=0 sb=0 sd=0 mult=2 m=2
XR11 net10 net11 VSS sky130_fd_pr__res_xhigh_po_0p69 L=6.9 mult=1 m=1
XR12 net12 net11 VSS sky130_fd_pr__res_xhigh_po_0p69 L=6.9 mult=1 m=1
XR13 net12 net13 VSS sky130_fd_pr__res_xhigh_po_0p69 L=6.9 mult=1 m=1
XR14 net14 net13 VSS sky130_fd_pr__res_xhigh_po_0p69 L=6.9 mult=1 m=1
XR15 net14 net15 VSS sky130_fd_pr__res_xhigh_po_0p69 L=6.9 mult=1 m=1
XR16 net19 VDD VSS sky130_fd_pr__res_xhigh_po_0p69 L=6.9 mult=1 m=1
XR17 net19 net18 VSS sky130_fd_pr__res_xhigh_po_0p69 L=6.9 mult=1 m=1
XR18 net17 net18 VSS sky130_fd_pr__res_xhigh_po_0p69 L=6.9 mult=1 m=1
XR19 net17 net16 VSS sky130_fd_pr__res_xhigh_po_0p69 L=6.9 mult=1 m=1
XR20 net15 net16 VSS sky130_fd_pr__res_xhigh_po_0p69 L=6.9 mult=1 m=1
XR21 VSS VSS VSS sky130_fd_pr__res_xhigh_po_0p69 L=6.9 mult=1 m=1
XR22 VSS VSS VSS sky130_fd_pr__res_xhigh_po_0p69 L=6.9 mult=1 m=1
.ends

.GLOBAL GND
.end
