* NGSPICE file created from error-amplifier_flat.ext - technology: sky130A

.subckt error-amplifier_flat VIN VP VN IBIAS_5uA OUT VSS
X0 VIN.t15 IBIAS_5uA.t0 IBIAS_5uA.t1 VIN.t14 sky130_fd_pr__pfet_01v8 ad=0.23925 pd=1.94 as=0.23925 ps=1.94 w=1.65 l=0.6
X1 a_1538_n1870.t3 VN.t0 a_1716_n1252.t1 VIN.t2 sky130_fd_pr__pfet_01v8 ad=2.03 pd=14.58 as=1.015 ps=7.29 w=7 l=0.6
X2 VIN.t13 IBIAS_5uA.t8 a_1716_n1252.t10 VIN.t12 sky130_fd_pr__pfet_01v8 ad=0.23925 pd=1.94 as=0.23925 ps=1.94 w=1.65 l=0.6
X3 a_1716_n1252.t0 VP.t0 OUT.t3 VIN.t0 sky130_fd_pr__pfet_01v8 ad=1.015 pd=7.29 as=1.015 ps=7.29 w=7 l=0.6
X4 OUT.t2 VP.t1 a_1716_n1252.t6 VIN.t5 sky130_fd_pr__pfet_01v8 ad=1.015 pd=7.29 as=1.015 ps=7.29 w=7 l=0.6
X5 a_1538_n1870.t9 a_1538_n1870.t8 VSS.t15 VSS.t14 sky130_fd_pr__nfet_01v8 ad=0.15225 pd=1.34 as=0.15225 ps=1.34 w=1.05 l=0.6
X6 a_1716_n1252.t9 IBIAS_5uA.t9 VIN.t11 VIN.t5 sky130_fd_pr__pfet_01v8 ad=0.23925 pd=1.94 as=0.23925 ps=1.94 w=1.65 l=0.6
X7 VSS.t13 a_1538_n1870.t6 a_1538_n1870.t7 VSS.t12 sky130_fd_pr__nfet_01v8 ad=0.15225 pd=1.34 as=0.15225 ps=1.34 w=1.05 l=0.6
X8 IBIAS_5uA.t7 IBIAS_5uA.t6 VIN.t10 VIN.t1 sky130_fd_pr__pfet_01v8 ad=0.23925 pd=1.94 as=0.23925 ps=1.94 w=1.65 l=0.6
X9 IBIAS_5uA.t3 IBIAS_5uA.t2 VIN.t9 VIN.t2 sky130_fd_pr__pfet_01v8 ad=0.4785 pd=3.88 as=0.23925 ps=1.94 w=1.65 l=0.6
X10 VSS.t11 a_1538_n1870.t12 OUT.t5 VSS.t10 sky130_fd_pr__nfet_01v8 ad=0.15225 pd=1.34 as=0.15225 ps=1.34 w=1.05 l=0.6
X11 a_1538_n1870.t2 VN.t1 a_1716_n1252.t4 VIN.t1 sky130_fd_pr__pfet_01v8 ad=1.015 pd=7.29 as=1.015 ps=7.29 w=7 l=0.6
X12 a_1716_n1252.t8 IBIAS_5uA.t10 VIN.t8 VIN.t4 sky130_fd_pr__pfet_01v8 ad=0.23925 pd=1.94 as=0.23925 ps=1.94 w=1.65 l=0.6
X13 OUT.t4 a_1538_n1870.t13 VSS.t9 VSS.t8 sky130_fd_pr__nfet_01v8 ad=0.15225 pd=1.34 as=0.15225 ps=1.34 w=1.05 l=0.6
X14 a_1716_n1252.t2 VN.t2 a_1538_n1870.t1 VIN.t14 sky130_fd_pr__pfet_01v8 ad=1.015 pd=7.29 as=1.015 ps=7.29 w=7 l=0.6
X15 VSS.t7 a_1538_n1870.t10 a_1538_n1870.t11 VSS.t6 sky130_fd_pr__nfet_01v8 ad=0.15225 pd=1.34 as=0.3045 ps=2.68 w=1.05 l=0.6
X16 a_1716_n1252.t11 VP.t2 OUT.t1 VIN.t12 sky130_fd_pr__pfet_01v8 ad=1.015 pd=7.29 as=1.015 ps=7.29 w=7 l=0.6
X17 a_1538_n1870.t5 a_1538_n1870.t4 VSS.t5 VSS.t4 sky130_fd_pr__nfet_01v8 ad=0.3045 pd=2.68 as=0.15225 ps=1.34 w=1.05 l=0.6
X18 OUT.t0 VP.t3 a_1716_n1252.t5 VIN.t4 sky130_fd_pr__pfet_01v8 ad=1.015 pd=7.29 as=1.015 ps=7.29 w=7 l=0.6
X19 VIN.t7 IBIAS_5uA.t11 a_1716_n1252.t7 VIN.t0 sky130_fd_pr__pfet_01v8 ad=0.23925 pd=1.94 as=0.23925 ps=1.94 w=1.65 l=0.6
X20 VSS.t3 a_1538_n1870.t14 OUT.t6 VSS.t2 sky130_fd_pr__nfet_01v8 ad=0.15225 pd=1.34 as=0.15225 ps=1.34 w=1.05 l=0.6
X21 a_1716_n1252.t3 VN.t3 a_1538_n1870.t0 VIN.t3 sky130_fd_pr__pfet_01v8 ad=1.015 pd=7.29 as=2.03 ps=14.58 w=7 l=0.6
X22 VIN.t6 IBIAS_5uA.t4 IBIAS_5uA.t5 VIN.t3 sky130_fd_pr__pfet_01v8 ad=0.23925 pd=1.94 as=0.4785 ps=3.88 w=1.65 l=0.6
X23 OUT.t7 a_1538_n1870.t15 VSS.t1 VSS.t0 sky130_fd_pr__nfet_01v8 ad=0.15225 pd=1.34 as=0.15225 ps=1.34 w=1.05 l=0.6
R0 IBIAS_5uA.n9 IBIAS_5uA.t4 253.282
R1 IBIAS_5uA.n8 IBIAS_5uA.t10 253.282
R2 IBIAS_5uA.n7 IBIAS_5uA.t8 253.282
R3 IBIAS_5uA.n6 IBIAS_5uA.t6 253.282
R4 IBIAS_5uA.n3 IBIAS_5uA.t0 253.282
R5 IBIAS_5uA.n2 IBIAS_5uA.t9 253.282
R6 IBIAS_5uA.n1 IBIAS_5uA.t11 253.282
R7 IBIAS_5uA.n0 IBIAS_5uA.t2 253.282
R8 IBIAS_5uA.n0 IBIAS_5uA.t3 215.909
R9 IBIAS_5uA.n10 IBIAS_5uA.t5 215.798
R10 IBIAS_5uA.n5 IBIAS_5uA.n4 198.368
R11 IBIAS_5uA.n4 IBIAS_5uA.t1 17.3126
R12 IBIAS_5uA.n4 IBIAS_5uA.t7 17.3126
R13 IBIAS_5uA IBIAS_5uA.n10 4.41591
R14 IBIAS_5uA.n1 IBIAS_5uA.n0 0.223
R15 IBIAS_5uA.n2 IBIAS_5uA.n1 0.223
R16 IBIAS_5uA.n3 IBIAS_5uA.n2 0.223
R17 IBIAS_5uA.n7 IBIAS_5uA.n6 0.223
R18 IBIAS_5uA.n8 IBIAS_5uA.n7 0.223
R19 IBIAS_5uA.n9 IBIAS_5uA.n8 0.223
R20 IBIAS_5uA.n10 IBIAS_5uA.n9 0.108
R21 IBIAS_5uA.n5 IBIAS_5uA.n3 0.048
R22 IBIAS_5uA.n6 IBIAS_5uA.n5 0.038
R23 VIN.n30 VIN.n14 5788.23
R24 VIN.n14 VIN.n12 5788.23
R25 VIN.n30 VIN.n16 5788.23
R26 VIN.n16 VIN.n12 5788.23
R27 VIN.n32 VIN.n9 3900
R28 VIN.n32 VIN.n10 3900
R29 VIN.n11 VIN.n9 3900
R30 VIN.n11 VIN.n10 3900
R31 VIN.n26 VIN.n25 298.865
R32 VIN.n27 VIN.n26 251.119
R33 VIN.n39 VIN.n2 237.971
R34 VIN.n8 VIN.n7 237.971
R35 VIN.n6 VIN.n5 237.971
R36 VIN.n21 VIN.n18 237.971
R37 VIN.n25 VIN.n24 144.712
R38 VIN.n28 VIN.n27 104.192
R39 VIN.n13 VIN.t2 71.4264
R40 VIN.n15 VIN.t3 71.4264
R41 VIN.t2 VIN.t0 62.6301
R42 VIN.t0 VIN.t5 62.6301
R43 VIN.t5 VIN.t14 62.6301
R44 VIN.t12 VIN.t1 62.6301
R45 VIN.t4 VIN.t12 62.6301
R46 VIN.t3 VIN.t4 62.6301
R47 VIN.n23 VIN.n22 51.5432
R48 VIN.n24 VIN.n23 49.6005
R49 VIN.n28 VIN.n1 35.7125
R50 VIN.n41 VIN.n1 34.6885
R51 VIN.n31 VIN.t14 31.3153
R52 VIN.n31 VIN.t1 31.3153
R53 VIN.n10 VIN.n1 30.8338
R54 VIN.n15 VIN.n10 30.8338
R55 VIN.n23 VIN.n9 30.8338
R56 VIN.n13 VIN.n9 30.8338
R57 VIN.n29 VIN.n24 29.0758
R58 VIN.n29 VIN.n28 28.5252
R59 VIN.n2 VIN.t8 17.3126
R60 VIN.n2 VIN.t6 17.3126
R61 VIN.n7 VIN.t10 17.3126
R62 VIN.n7 VIN.t13 17.3126
R63 VIN.n5 VIN.t11 17.3126
R64 VIN.n5 VIN.t15 17.3126
R65 VIN.n18 VIN.t9 17.3126
R66 VIN.n18 VIN.t7 17.3126
R67 VIN.n20 VIN.n19 14.7205
R68 VIN.n38 VIN.n3 14.0805
R69 VIN.n33 VIN.n8 11.7765
R70 VIN.n41 VIN.n40 11.5205
R71 VIN.n22 VIN.n21 10.8032
R72 VIN.n34 VIN.n6 10.5605
R73 VIN.n26 VIN.n12 8.40959
R74 VIN.n31 VIN.n12 8.40959
R75 VIN.n25 VIN.n14 8.40959
R76 VIN.n14 VIN.n13 8.40959
R77 VIN.n27 VIN.n16 8.40959
R78 VIN.n16 VIN.n15 8.40959
R79 VIN.n30 VIN.n29 8.40959
R80 VIN.n31 VIN.n30 8.40959
R81 VIN.n29 VIN.n11 8.40959
R82 VIN.n31 VIN.n11 8.40959
R83 VIN.n33 VIN.n32 8.40959
R84 VIN.n32 VIN.n31 8.40959
R85 VIN.n40 VIN.n39 7.3605
R86 VIN.n39 VIN.n38 6.7205
R87 VIN.n21 VIN.n20 4.1605
R88 VIN.n19 VIN.n6 4.1605
R89 VIN.n42 VIN.n41 4.1105
R90 VIN.n8 VIN.n3 1.6005
R91 VIN.n40 VIN.n0 1.5505
R92 VIN.n38 VIN.n37 1.5505
R93 VIN.n36 VIN.n3 1.5505
R94 VIN.n35 VIN.n34 1.5505
R95 VIN.n19 VIN.n4 1.5505
R96 VIN.n20 VIN.n17 1.5505
R97 VIN.n34 VIN.n33 0.7045
R98 VIN.n22 VIN.n17 0.667608
R99 VIN.n17 VIN.n4 0.14425
R100 VIN.n35 VIN.n4 0.14425
R101 VIN.n36 VIN.n35 0.138
R102 VIN.n37 VIN.n36 0.138
R103 VIN.n37 VIN.n0 0.138
R104 VIN.n42 VIN.n0 0.138
R105 VIN VIN.n42 0.06925
R106 VN.n0 VN.t0 473.726
R107 VN.n2 VN.t3 473.051
R108 VN.n1 VN.t1 473.051
R109 VN.n0 VN.t2 473.051
R110 VN VN.n2 3.13275
R111 VN.n2 VN.n1 0.663
R112 VN.n1 VN.n0 0.2255
R113 a_1716_n1252.n5 a_1716_n1252.n3 202.269
R114 a_1716_n1252.n5 a_1716_n1252.n4 202.266
R115 a_1716_n1252.n11 a_1716_n1252.n10 29.74
R116 a_1716_n1252.n26 a_1716_n1252.n25 29.74
R117 a_1716_n1252.n43 a_1716_n1252.n42 29.74
R118 a_1716_n1252.n65 a_1716_n1252.n64 29.74
R119 a_1716_n1252.n3 a_1716_n1252.t7 17.3126
R120 a_1716_n1252.n3 a_1716_n1252.t9 17.3126
R121 a_1716_n1252.n4 a_1716_n1252.t10 17.3126
R122 a_1716_n1252.n4 a_1716_n1252.t8 17.3126
R123 a_1716_n1252.n18 a_1716_n1252.n17 4.5005
R124 a_1716_n1252.n9 a_1716_n1252.n8 4.5005
R125 a_1716_n1252.n13 a_1716_n1252.n12 4.5005
R126 a_1716_n1252.n33 a_1716_n1252.n32 4.5005
R127 a_1716_n1252.n24 a_1716_n1252.n23 4.5005
R128 a_1716_n1252.n28 a_1716_n1252.n27 4.5005
R129 a_1716_n1252.n50 a_1716_n1252.n49 4.5005
R130 a_1716_n1252.n41 a_1716_n1252.n40 4.5005
R131 a_1716_n1252.n45 a_1716_n1252.n44 4.5005
R132 a_1716_n1252.n59 a_1716_n1252.n2 4.5005
R133 a_1716_n1252.n61 a_1716_n1252.n60 4.5005
R134 a_1716_n1252.n62 a_1716_n1252.n0 4.5005
R135 a_1716_n1252.n10 a_1716_n1252.t5 4.08121
R136 a_1716_n1252.n10 a_1716_n1252.t3 4.08121
R137 a_1716_n1252.n25 a_1716_n1252.t4 4.08121
R138 a_1716_n1252.n25 a_1716_n1252.t11 4.08121
R139 a_1716_n1252.n42 a_1716_n1252.t6 4.08121
R140 a_1716_n1252.n42 a_1716_n1252.t2 4.08121
R141 a_1716_n1252.n65 a_1716_n1252.t1 4.08121
R142 a_1716_n1252.t0 a_1716_n1252.n65 4.08121
R143 a_1716_n1252.n20 a_1716_n1252.n19 3.47871
R144 a_1716_n1252.n35 a_1716_n1252.n34 3.47871
R145 a_1716_n1252.n52 a_1716_n1252.n51 3.47871
R146 a_1716_n1252.n58 a_1716_n1252.n54 3.47871
R147 a_1716_n1252.n15 a_1716_n1252.n9 3.4105
R148 a_1716_n1252.n17 a_1716_n1252.n16 3.4105
R149 a_1716_n1252.n7 a_1716_n1252.n6 3.4105
R150 a_1716_n1252.n30 a_1716_n1252.n24 3.4105
R151 a_1716_n1252.n32 a_1716_n1252.n31 3.4105
R152 a_1716_n1252.n22 a_1716_n1252.n21 3.4105
R153 a_1716_n1252.n47 a_1716_n1252.n41 3.4105
R154 a_1716_n1252.n49 a_1716_n1252.n48 3.4105
R155 a_1716_n1252.n39 a_1716_n1252.n38 3.4105
R156 a_1716_n1252.n61 a_1716_n1252.n1 3.4105
R157 a_1716_n1252.n55 a_1716_n1252.n2 3.4105
R158 a_1716_n1252.n57 a_1716_n1252.n56 3.4105
R159 a_1716_n1252.n19 a_1716_n1252.n18 2.38642
R160 a_1716_n1252.n34 a_1716_n1252.n33 2.38642
R161 a_1716_n1252.n51 a_1716_n1252.n50 2.38642
R162 a_1716_n1252.n59 a_1716_n1252.n58 2.38642
R163 a_1716_n1252.n14 a_1716_n1252.n11 1.34877
R164 a_1716_n1252.n29 a_1716_n1252.n26 1.34877
R165 a_1716_n1252.n46 a_1716_n1252.n43 1.34877
R166 a_1716_n1252.n64 a_1716_n1252.n63 1.3479
R167 a_1716_n1252.n63 a_1716_n1252.n1 0.757265
R168 a_1716_n1252.n15 a_1716_n1252.n14 0.756722
R169 a_1716_n1252.n30 a_1716_n1252.n29 0.756722
R170 a_1716_n1252.n47 a_1716_n1252.n46 0.756722
R171 a_1716_n1252.n37 a_1716_n1252.n5 0.244045
R172 a_1716_n1252.n36 a_1716_n1252.n20 0.206837
R173 a_1716_n1252.n54 a_1716_n1252.n53 0.206837
R174 a_1716_n1252.n14 a_1716_n1252.n13 0.177197
R175 a_1716_n1252.n29 a_1716_n1252.n28 0.177197
R176 a_1716_n1252.n46 a_1716_n1252.n45 0.177197
R177 a_1716_n1252.n63 a_1716_n1252.n62 0.177161
R178 a_1716_n1252.n18 a_1716_n1252.n8 0.135917
R179 a_1716_n1252.n12 a_1716_n1252.n8 0.135917
R180 a_1716_n1252.n17 a_1716_n1252.n7 0.135917
R181 a_1716_n1252.n17 a_1716_n1252.n9 0.135917
R182 a_1716_n1252.n13 a_1716_n1252.n9 0.135917
R183 a_1716_n1252.n33 a_1716_n1252.n23 0.135917
R184 a_1716_n1252.n27 a_1716_n1252.n23 0.135917
R185 a_1716_n1252.n32 a_1716_n1252.n22 0.135917
R186 a_1716_n1252.n32 a_1716_n1252.n24 0.135917
R187 a_1716_n1252.n28 a_1716_n1252.n24 0.135917
R188 a_1716_n1252.n50 a_1716_n1252.n40 0.135917
R189 a_1716_n1252.n44 a_1716_n1252.n40 0.135917
R190 a_1716_n1252.n49 a_1716_n1252.n39 0.135917
R191 a_1716_n1252.n49 a_1716_n1252.n41 0.135917
R192 a_1716_n1252.n45 a_1716_n1252.n41 0.135917
R193 a_1716_n1252.n57 a_1716_n1252.n2 0.135917
R194 a_1716_n1252.n61 a_1716_n1252.n2 0.135917
R195 a_1716_n1252.n62 a_1716_n1252.n61 0.135917
R196 a_1716_n1252.n60 a_1716_n1252.n59 0.135917
R197 a_1716_n1252.n60 a_1716_n1252.n0 0.135917
R198 a_1716_n1252.n36 a_1716_n1252.n35 0.104292
R199 a_1716_n1252.n53 a_1716_n1252.n52 0.104292
R200 a_1716_n1252.n12 a_1716_n1252.n11 0.0755
R201 a_1716_n1252.n27 a_1716_n1252.n26 0.0755
R202 a_1716_n1252.n44 a_1716_n1252.n43 0.0755
R203 a_1716_n1252.n64 a_1716_n1252.n0 0.0755
R204 a_1716_n1252.n19 a_1716_n1252.n7 0.0667303
R205 a_1716_n1252.n34 a_1716_n1252.n22 0.0667303
R206 a_1716_n1252.n51 a_1716_n1252.n39 0.0667303
R207 a_1716_n1252.n58 a_1716_n1252.n57 0.0667303
R208 a_1716_n1252.n53 a_1716_n1252.n37 0.0539091
R209 a_1716_n1252.n20 a_1716_n1252.n6 0.0514167
R210 a_1716_n1252.n16 a_1716_n1252.n6 0.0514167
R211 a_1716_n1252.n16 a_1716_n1252.n15 0.0514167
R212 a_1716_n1252.n35 a_1716_n1252.n21 0.0514167
R213 a_1716_n1252.n31 a_1716_n1252.n21 0.0514167
R214 a_1716_n1252.n31 a_1716_n1252.n30 0.0514167
R215 a_1716_n1252.n52 a_1716_n1252.n38 0.0514167
R216 a_1716_n1252.n48 a_1716_n1252.n38 0.0514167
R217 a_1716_n1252.n48 a_1716_n1252.n47 0.0514167
R218 a_1716_n1252.n56 a_1716_n1252.n54 0.0514167
R219 a_1716_n1252.n56 a_1716_n1252.n55 0.0514167
R220 a_1716_n1252.n55 a_1716_n1252.n1 0.0514167
R221 a_1716_n1252.n37 a_1716_n1252.n36 0.0496364
R222 a_1538_n1870.n49 a_1538_n1870.t10 203.476
R223 a_1538_n1870.n50 a_1538_n1870.t13 203.476
R224 a_1538_n1870.n51 a_1538_n1870.t12 203.476
R225 a_1538_n1870.n52 a_1538_n1870.t8 203.476
R226 a_1538_n1870.n47 a_1538_n1870.t6 203.476
R227 a_1538_n1870.n46 a_1538_n1870.t15 203.476
R228 a_1538_n1870.n45 a_1538_n1870.t14 203.476
R229 a_1538_n1870.n44 a_1538_n1870.t4 203.476
R230 a_1538_n1870.n43 a_1538_n1870.t5 81.3798
R231 a_1538_n1870.n48 a_1538_n1870.t11 81.3797
R232 a_1538_n1870.n42 a_1538_n1870.n41 64.7672
R233 a_1538_n1870.n11 a_1538_n1870.t0 33.8207
R234 a_1538_n1870.t3 a_1538_n1870.n70 33.8207
R235 a_1538_n1870.n29 a_1538_n1870.n28 29.74
R236 a_1538_n1870.n41 a_1538_n1870.t7 16.5719
R237 a_1538_n1870.n41 a_1538_n1870.t9 16.5719
R238 a_1538_n1870.n56 a_1538_n1870.n42 4.59425
R239 a_1538_n1870.n19 a_1538_n1870.n18 4.5005
R240 a_1538_n1870.n8 a_1538_n1870.n7 4.5005
R241 a_1538_n1870.n14 a_1538_n1870.n13 4.5005
R242 a_1538_n1870.n12 a_1538_n1870.n10 4.5005
R243 a_1538_n1870.n37 a_1538_n1870.n36 4.5005
R244 a_1538_n1870.n25 a_1538_n1870.n24 4.5005
R245 a_1538_n1870.n32 a_1538_n1870.n31 4.5005
R246 a_1538_n1870.n30 a_1538_n1870.n27 4.5005
R247 a_1538_n1870.n55 a_1538_n1870.n54 4.5005
R248 a_1538_n1870.n69 a_1538_n1870.n68 4.5005
R249 a_1538_n1870.n67 a_1538_n1870.n1 4.5005
R250 a_1538_n1870.n66 a_1538_n1870.n65 4.5005
R251 a_1538_n1870.n64 a_1538_n1870.n4 4.5005
R252 a_1538_n1870.n43 a_1538_n1870.n40 4.2667
R253 a_1538_n1870.n48 a_1538_n1870.n40 4.26246
R254 a_1538_n1870.n28 a_1538_n1870.t1 4.08121
R255 a_1538_n1870.n28 a_1538_n1870.t2 4.08121
R256 a_1538_n1870.n21 a_1538_n1870.n20 3.47871
R257 a_1538_n1870.n39 a_1538_n1870.n38 3.47871
R258 a_1538_n1870.n63 a_1538_n1870.n59 3.47869
R259 a_1538_n1870.n55 a_1538_n1870.n40 3.4152
R260 a_1538_n1870.n6 a_1538_n1870.n5 3.4105
R261 a_1538_n1870.n18 a_1538_n1870.n17 3.4105
R262 a_1538_n1870.n16 a_1538_n1870.n8 3.4105
R263 a_1538_n1870.n15 a_1538_n1870.n14 3.4105
R264 a_1538_n1870.n57 a_1538_n1870.n56 3.4105
R265 a_1538_n1870.n23 a_1538_n1870.n22 3.4105
R266 a_1538_n1870.n36 a_1538_n1870.n35 3.4105
R267 a_1538_n1870.n34 a_1538_n1870.n25 3.4105
R268 a_1538_n1870.n33 a_1538_n1870.n32 3.4105
R269 a_1538_n1870.n62 a_1538_n1870.n61 3.4105
R270 a_1538_n1870.n60 a_1538_n1870.n4 3.4105
R271 a_1538_n1870.n66 a_1538_n1870.n3 3.4105
R272 a_1538_n1870.n67 a_1538_n1870.n2 3.4105
R273 a_1538_n1870.n20 a_1538_n1870.n19 2.38642
R274 a_1538_n1870.n38 a_1538_n1870.n37 2.38642
R275 a_1538_n1870.n64 a_1538_n1870.n63 2.38366
R276 a_1538_n1870.n11 a_1538_n1870.n9 1.22589
R277 a_1538_n1870.n29 a_1538_n1870.n26 1.22589
R278 a_1538_n1870.n70 a_1538_n1870.n0 1.22127
R279 a_1538_n1870.n2 a_1538_n1870.n0 0.660297
R280 a_1538_n1870.n15 a_1538_n1870.n9 0.660172
R281 a_1538_n1870.n33 a_1538_n1870.n26 0.660172
R282 a_1538_n1870.n45 a_1538_n1870.n44 0.384121
R283 a_1538_n1870.n46 a_1538_n1870.n45 0.384121
R284 a_1538_n1870.n47 a_1538_n1870.n46 0.384121
R285 a_1538_n1870.n52 a_1538_n1870.n51 0.384121
R286 a_1538_n1870.n51 a_1538_n1870.n50 0.384121
R287 a_1538_n1870.n50 a_1538_n1870.n49 0.384121
R288 a_1538_n1870.n58 a_1538_n1870.n21 0.27164
R289 a_1538_n1870.n59 a_1538_n1870.n58 0.27164
R290 a_1538_n1870.n44 a_1538_n1870.n43 0.24901
R291 a_1538_n1870.n49 a_1538_n1870.n48 0.244753
R292 a_1538_n1870.n58 a_1538_n1870.n57 0.219442
R293 a_1538_n1870.n68 a_1538_n1870.n0 0.203997
R294 a_1538_n1870.n10 a_1538_n1870.n9 0.203925
R295 a_1538_n1870.n27 a_1538_n1870.n26 0.203925
R296 a_1538_n1870.n56 a_1538_n1870.n55 0.1755
R297 a_1538_n1870.n13 a_1538_n1870.n12 0.135917
R298 a_1538_n1870.n13 a_1538_n1870.n7 0.135917
R299 a_1538_n1870.n19 a_1538_n1870.n7 0.135917
R300 a_1538_n1870.n14 a_1538_n1870.n10 0.135917
R301 a_1538_n1870.n14 a_1538_n1870.n8 0.135917
R302 a_1538_n1870.n18 a_1538_n1870.n8 0.135917
R303 a_1538_n1870.n18 a_1538_n1870.n6 0.135917
R304 a_1538_n1870.n31 a_1538_n1870.n30 0.135917
R305 a_1538_n1870.n31 a_1538_n1870.n24 0.135917
R306 a_1538_n1870.n37 a_1538_n1870.n24 0.135917
R307 a_1538_n1870.n32 a_1538_n1870.n27 0.135917
R308 a_1538_n1870.n32 a_1538_n1870.n25 0.135917
R309 a_1538_n1870.n36 a_1538_n1870.n25 0.135917
R310 a_1538_n1870.n36 a_1538_n1870.n23 0.135917
R311 a_1538_n1870.n68 a_1538_n1870.n67 0.135917
R312 a_1538_n1870.n67 a_1538_n1870.n66 0.135917
R313 a_1538_n1870.n66 a_1538_n1870.n4 0.135917
R314 a_1538_n1870.n62 a_1538_n1870.n4 0.135917
R315 a_1538_n1870.n69 a_1538_n1870.n1 0.133697
R316 a_1538_n1870.n65 a_1538_n1870.n1 0.133697
R317 a_1538_n1870.n65 a_1538_n1870.n64 0.133697
R318 a_1538_n1870.n54 a_1538_n1870.n53 0.12675
R319 a_1538_n1870.n53 a_1538_n1870.n52 0.0867069
R320 a_1538_n1870.n53 a_1538_n1870.n47 0.0823966
R321 a_1538_n1870.n54 a_1538_n1870.n42 0.08175
R322 a_1538_n1870.n63 a_1538_n1870.n62 0.0667461
R323 a_1538_n1870.n20 a_1538_n1870.n6 0.0667303
R324 a_1538_n1870.n38 a_1538_n1870.n23 0.0667303
R325 a_1538_n1870.n16 a_1538_n1870.n15 0.0514167
R326 a_1538_n1870.n17 a_1538_n1870.n16 0.0514167
R327 a_1538_n1870.n17 a_1538_n1870.n5 0.0514167
R328 a_1538_n1870.n21 a_1538_n1870.n5 0.0514167
R329 a_1538_n1870.n34 a_1538_n1870.n33 0.0514167
R330 a_1538_n1870.n35 a_1538_n1870.n34 0.0514167
R331 a_1538_n1870.n35 a_1538_n1870.n22 0.0514167
R332 a_1538_n1870.n39 a_1538_n1870.n22 0.0514167
R333 a_1538_n1870.n3 a_1538_n1870.n2 0.0514167
R334 a_1538_n1870.n60 a_1538_n1870.n3 0.0514167
R335 a_1538_n1870.n61 a_1538_n1870.n60 0.0514167
R336 a_1538_n1870.n61 a_1538_n1870.n59 0.0514167
R337 a_1538_n1870.n57 a_1538_n1870.n40 0.0099
R338 a_1538_n1870.n12 a_1538_n1870.n11 0.00883333
R339 a_1538_n1870.n30 a_1538_n1870.n29 0.00883333
R340 a_1538_n1870.n70 a_1538_n1870.n69 0.00869672
R341 a_1538_n1870.n58 a_1538_n1870.n39 0.00245833
R342 VP.n0 VP.t0 473.053
R343 VP.n2 VP.t3 472.827
R344 VP.n1 VP.t2 472.827
R345 VP.n0 VP.t1 472.827
R346 VP VP.n2 3.35775
R347 VP.n1 VP.n0 0.663
R348 VP.n2 VP.n1 0.2255
R349 OUT.n2 OUT.n1 67.4008
R350 OUT.n5 OUT.n4 67.4008
R351 OUT.n2 OUT.n0 31.1036
R352 OUT.n5 OUT.n3 31.1036
R353 OUT.n1 OUT.t5 16.5719
R354 OUT.n1 OUT.t4 16.5719
R355 OUT.n4 OUT.t6 16.5719
R356 OUT.n4 OUT.t7 16.5719
R357 OUT.n0 OUT.t1 4.08121
R358 OUT.n0 OUT.t0 4.08121
R359 OUT.n3 OUT.t3 4.08121
R360 OUT.n3 OUT.t2 4.08121
R361 OUT OUT.n5 3.30108
R362 OUT.n5 OUT.n2 0.7505
R363 VSS.n5 VSS.n4 117227
R364 VSS.n16 VSS.n2 6025.88
R365 VSS.n16 VSS.n3 6025.88
R366 VSS.n18 VSS.n3 6025.88
R367 VSS.n18 VSS.n2 6025.88
R368 VSS.n4 VSS.t4 1116.5
R369 VSS.t6 VSS.n5 1116.5
R370 VSS.t4 VSS.t2 979
R371 VSS.t2 VSS.t0 979
R372 VSS.t0 VSS.t12 979
R373 VSS.t14 VSS.t10 979
R374 VSS.t10 VSS.t8 979
R375 VSS.t8 VSS.t6 979
R376 VSS.n17 VSS.t12 489.5
R377 VSS.n17 VSS.t14 489.5
R378 VSS.n8 VSS.n6 177.319
R379 VSS.n13 VSS.n1 177.319
R380 VSS.n6 VSS.n2 146.25
R381 VSS.n4 VSS.n2 146.25
R382 VSS.n3 VSS.n1 146.25
R383 VSS.n5 VSS.n3 146.25
R384 VSS.n10 VSS.n8 107.671
R385 VSS.n14 VSS.n13 107.671
R386 VSS.n8 VSS.n7 98.2386
R387 VSS.n10 VSS.n9 98.2386
R388 VSS.n14 VSS.n11 98.2386
R389 VSS.n13 VSS.n12 98.2386
R390 VSS.n6 VSS.n0 81.3573
R391 VSS.n20 VSS.n1 80.3956
R392 VSS.n15 VSS.n10 53.8358
R393 VSS.n15 VSS.n14 53.8358
R394 VSS.n16 VSS.n15 26.5914
R395 VSS.n17 VSS.n16 26.5914
R396 VSS.n19 VSS.n18 26.5914
R397 VSS.n18 VSS.n17 26.5914
R398 VSS.n7 VSS.t5 16.5719
R399 VSS.n7 VSS.t3 16.5719
R400 VSS.n9 VSS.t1 16.5719
R401 VSS.n9 VSS.t13 16.5719
R402 VSS.n11 VSS.t15 16.5719
R403 VSS.n11 VSS.t11 16.5719
R404 VSS.n12 VSS.t9 16.5719
R405 VSS.n12 VSS.t7 16.5719
R406 VSS.n20 VSS.n19 13.4906
R407 VSS.n19 VSS.n0 3.381
R408 VSS VSS.n20 0.0863367
R409 VSS VSS.n0 0.0838949
C0 IBIAS_5uA VP 0.15751f
C1 VIN VP 1.59107f
C2 IBIAS_5uA VIN 3.42741f
C3 VN VP 2.36491f
C4 IBIAS_5uA VN 0.59855f
C5 VN VIN 1.79253f
C6 OUT VP 0.76695f
C7 IBIAS_5uA OUT 0.00969f
C8 OUT VIN 0.29453f
C9 OUT VN 0.0743f
C10 OUT VSS 1.90239f
C11 VP VSS 0.7105f
C12 VN VSS 0.78304f
C13 IBIAS_5uA VSS 1.4008f
C14 VIN VSS 16.98745f
C15 OUT.t1 VSS 0.09379f
C16 OUT.t0 VSS 0.09379f
C17 OUT.n0 VSS 0.2444f
C18 OUT.t5 VSS 0.01407f
C19 OUT.t4 VSS 0.01407f
C20 OUT.n1 VSS 0.03584f
C21 OUT.n2 VSS 1.99364f
C22 OUT.t3 VSS 0.09379f
C23 OUT.t2 VSS 0.09379f
C24 OUT.n3 VSS 0.2444f
C25 OUT.t6 VSS 0.01407f
C26 OUT.t7 VSS 0.01407f
C27 OUT.n4 VSS 0.03584f
C28 OUT.n5 VSS 2.54647f
C29 VP.t0 VSS 0.30308f
C30 VP.t1 VSS 0.30296f
C31 VP.n0 VSS 0.51423f
C32 VP.t2 VSS 0.30296f
C33 VP.n1 VSS 0.24587f
C34 VP.t3 VSS 0.30296f
C35 VP.n2 VSS 0.35359f
C36 a_1538_n1870.n0 VSS 0.22561f
C37 a_1538_n1870.n1 VSS 0.04086f
C38 a_1538_n1870.n2 VSS 0.2504f
C39 a_1538_n1870.n3 VSS 0.04019f
C40 a_1538_n1870.n4 VSS 0.04019f
C41 a_1538_n1870.n5 VSS 0.04019f
C42 a_1538_n1870.n6 VSS 0.04019f
C43 a_1538_n1870.n7 VSS 0.04019f
C44 a_1538_n1870.n8 VSS 0.04019f
C45 a_1538_n1870.n9 VSS 0.22585f
C46 a_1538_n1870.n10 VSS 0.07185f
C47 a_1538_n1870.t0 VSS 0.19203f
C48 a_1538_n1870.n11 VSS 0.32993f
C49 a_1538_n1870.n12 VSS 0.02133f
C50 a_1538_n1870.n13 VSS 0.04019f
C51 a_1538_n1870.n14 VSS 0.04019f
C52 a_1538_n1870.n15 VSS 0.25041f
C53 a_1538_n1870.n16 VSS 0.04019f
C54 a_1538_n1870.n17 VSS 0.04019f
C55 a_1538_n1870.n18 VSS 0.04019f
C56 a_1538_n1870.n19 VSS 0.11347f
C57 a_1538_n1870.n20 VSS 0.0434f
C58 a_1538_n1870.n21 VSS 0.12791f
C59 a_1538_n1870.n22 VSS 0.04019f
C60 a_1538_n1870.n23 VSS 0.04019f
C61 a_1538_n1870.n24 VSS 0.04019f
C62 a_1538_n1870.n25 VSS 0.04019f
C63 a_1538_n1870.n26 VSS 0.22585f
C64 a_1538_n1870.n27 VSS 0.07185f
C65 a_1538_n1870.t1 VSS 0.05229f
C66 a_1538_n1870.t2 VSS 0.05229f
C67 a_1538_n1870.n28 VSS 0.10662f
C68 a_1538_n1870.n29 VSS 0.31075f
C69 a_1538_n1870.n30 VSS 0.02133f
C70 a_1538_n1870.n31 VSS 0.04019f
C71 a_1538_n1870.n32 VSS 0.04019f
C72 a_1538_n1870.n33 VSS 0.25041f
C73 a_1538_n1870.n34 VSS 0.04019f
C74 a_1538_n1870.n35 VSS 0.04019f
C75 a_1538_n1870.n36 VSS 0.04019f
C76 a_1538_n1870.n37 VSS 0.11347f
C77 a_1538_n1870.n38 VSS 0.0434f
C78 a_1538_n1870.n39 VSS 0.02165f
C79 a_1538_n1870.n40 VSS 0.56035f
C80 a_1538_n1870.t7 VSS 0.00784f
C81 a_1538_n1870.t9 VSS 0.00784f
C82 a_1538_n1870.n41 VSS 0.0166f
C83 a_1538_n1870.n42 VSS 0.05829f
C84 a_1538_n1870.t5 VSS 0.02734f
C85 a_1538_n1870.n43 VSS 0.12868f
C86 a_1538_n1870.t4 VSS 0.07299f
C87 a_1538_n1870.n44 VSS 0.05073f
C88 a_1538_n1870.t14 VSS 0.07299f
C89 a_1538_n1870.n45 VSS 0.04198f
C90 a_1538_n1870.t15 VSS 0.07299f
C91 a_1538_n1870.n46 VSS 0.04198f
C92 a_1538_n1870.t6 VSS 0.07299f
C93 a_1538_n1870.n47 VSS 0.03153f
C94 a_1538_n1870.t11 VSS 0.02734f
C95 a_1538_n1870.n48 VSS 0.12834f
C96 a_1538_n1870.t10 VSS 0.07299f
C97 a_1538_n1870.n49 VSS 0.05081f
C98 a_1538_n1870.t13 VSS 0.07299f
C99 a_1538_n1870.n50 VSS 0.04198f
C100 a_1538_n1870.t12 VSS 0.07299f
C101 a_1538_n1870.n51 VSS 0.04198f
C102 a_1538_n1870.t8 VSS 0.07299f
C103 a_1538_n1870.n52 VSS 0.03167f
C104 a_1538_n1870.n53 VSS 0.02631f
C105 a_1538_n1870.n54 VSS 0.02138f
C106 a_1538_n1870.n55 VSS 0.03093f
C107 a_1538_n1870.n56 VSS 0.03137f
C108 a_1538_n1870.n57 VSS 0.06283f
C109 a_1538_n1870.n58 VSS 0.24578f
C110 a_1538_n1870.n59 VSS 0.1279f
C111 a_1538_n1870.n60 VSS 0.04019f
C112 a_1538_n1870.n61 VSS 0.04019f
C113 a_1538_n1870.n62 VSS 0.04019f
C114 a_1538_n1870.n63 VSS 0.04248f
C115 a_1538_n1870.n64 VSS 0.10516f
C116 a_1538_n1870.n65 VSS 0.04086f
C117 a_1538_n1870.n66 VSS 0.04019f
C118 a_1538_n1870.n67 VSS 0.04019f
C119 a_1538_n1870.n68 VSS 0.07187f
C120 a_1538_n1870.n69 VSS 0.02169f
C121 a_1538_n1870.n70 VSS 0.33255f
C122 a_1538_n1870.t3 VSS 0.19203f
C123 a_1716_n1252.t1 VSS 0.09612f
C124 a_1716_n1252.n0 VSS 0.05739f
C125 a_1716_n1252.n1 VSS 0.40179f
C126 a_1716_n1252.n2 VSS 0.07387f
C127 a_1716_n1252.t7 VSS 0.02266f
C128 a_1716_n1252.t9 VSS 0.02266f
C129 a_1716_n1252.n3 VSS 0.05121f
C130 a_1716_n1252.t10 VSS 0.02266f
C131 a_1716_n1252.t8 VSS 0.02266f
C132 a_1716_n1252.n4 VSS 0.0512f
C133 a_1716_n1252.n5 VSS 1.37817f
C134 a_1716_n1252.n6 VSS 0.07387f
C135 a_1716_n1252.n7 VSS 0.07387f
C136 a_1716_n1252.n8 VSS 0.07387f
C137 a_1716_n1252.n9 VSS 0.07387f
C138 a_1716_n1252.t5 VSS 0.09612f
C139 a_1716_n1252.t3 VSS 0.09612f
C140 a_1716_n1252.n10 VSS 0.19598f
C141 a_1716_n1252.n11 VSS 0.48055f
C142 a_1716_n1252.n12 VSS 0.05739f
C143 a_1716_n1252.n13 VSS 0.11843f
C144 a_1716_n1252.n14 VSS 0.29647f
C145 a_1716_n1252.n15 VSS 0.40167f
C146 a_1716_n1252.n16 VSS 0.07387f
C147 a_1716_n1252.n17 VSS 0.07387f
C148 a_1716_n1252.n18 VSS 0.2346f
C149 a_1716_n1252.n19 VSS 0.11001f
C150 a_1716_n1252.n20 VSS 0.19824f
C151 a_1716_n1252.n21 VSS 0.07387f
C152 a_1716_n1252.n22 VSS 0.07387f
C153 a_1716_n1252.n23 VSS 0.07387f
C154 a_1716_n1252.n24 VSS 0.07387f
C155 a_1716_n1252.t4 VSS 0.09612f
C156 a_1716_n1252.t11 VSS 0.09612f
C157 a_1716_n1252.n25 VSS 0.19598f
C158 a_1716_n1252.n26 VSS 0.48055f
C159 a_1716_n1252.n27 VSS 0.05739f
C160 a_1716_n1252.n28 VSS 0.11843f
C161 a_1716_n1252.n29 VSS 0.29647f
C162 a_1716_n1252.n30 VSS 0.40167f
C163 a_1716_n1252.n31 VSS 0.07387f
C164 a_1716_n1252.n32 VSS 0.07387f
C165 a_1716_n1252.n33 VSS 0.2346f
C166 a_1716_n1252.n34 VSS 0.11001f
C167 a_1716_n1252.n35 VSS 0.11423f
C168 a_1716_n1252.n36 VSS 0.28403f
C169 a_1716_n1252.n37 VSS 0.21095f
C170 a_1716_n1252.n38 VSS 0.07387f
C171 a_1716_n1252.n39 VSS 0.07387f
C172 a_1716_n1252.n40 VSS 0.07387f
C173 a_1716_n1252.n41 VSS 0.07387f
C174 a_1716_n1252.t6 VSS 0.09612f
C175 a_1716_n1252.t2 VSS 0.09612f
C176 a_1716_n1252.n42 VSS 0.19598f
C177 a_1716_n1252.n43 VSS 0.48055f
C178 a_1716_n1252.n44 VSS 0.05739f
C179 a_1716_n1252.n45 VSS 0.11843f
C180 a_1716_n1252.n46 VSS 0.29647f
C181 a_1716_n1252.n47 VSS 0.40167f
C182 a_1716_n1252.n48 VSS 0.07387f
C183 a_1716_n1252.n49 VSS 0.07387f
C184 a_1716_n1252.n50 VSS 0.2346f
C185 a_1716_n1252.n51 VSS 0.11001f
C186 a_1716_n1252.n52 VSS 0.11423f
C187 a_1716_n1252.n53 VSS 0.28663f
C188 a_1716_n1252.n54 VSS 0.19824f
C189 a_1716_n1252.n55 VSS 0.07387f
C190 a_1716_n1252.n56 VSS 0.07387f
C191 a_1716_n1252.n57 VSS 0.07387f
C192 a_1716_n1252.n58 VSS 0.11001f
C193 a_1716_n1252.n59 VSS 0.2346f
C194 a_1716_n1252.n60 VSS 0.07387f
C195 a_1716_n1252.n61 VSS 0.07387f
C196 a_1716_n1252.n62 VSS 0.11843f
C197 a_1716_n1252.n63 VSS 0.29641f
C198 a_1716_n1252.n64 VSS 0.48048f
C199 a_1716_n1252.n65 VSS 0.19598f
C200 a_1716_n1252.t0 VSS 0.09612f
C201 VN.t0 VSS 0.30336f
C202 VN.t2 VSS 0.30297f
C203 VN.n0 VSS 0.51521f
C204 VN.t1 VSS 0.30297f
C205 VN.n1 VSS 0.24576f
C206 VN.t3 VSS 0.30297f
C207 VN.n2 VSS 0.36278f
C208 VIN.n0 VSS 0.02058f
C209 VIN.n1 VSS 0.01286f
C210 VIN.t8 VSS 0.00224f
C211 VIN.t6 VSS 0.00224f
C212 VIN.n2 VSS 0.00621f
C213 VIN.n3 VSS 0.01146f
C214 VIN.n4 VSS 0.02152f
C215 VIN.t11 VSS 0.00224f
C216 VIN.t15 VSS 0.00224f
C217 VIN.n5 VSS 0.00621f
C218 VIN.n6 VSS 0.02245f
C219 VIN.t10 VSS 0.00224f
C220 VIN.t13 VSS 0.00224f
C221 VIN.n7 VSS 0.00621f
C222 VIN.n8 VSS 0.02147f
C223 VIN.n9 VSS 0.01798f
C224 VIN.n10 VSS 0.01798f
C225 VIN.t14 VSS 0.16861f
C226 VIN.n11 VSS 0.01771f
C227 VIN.n12 VSS 0.02635f
C228 VIN.t1 VSS 0.16861f
C229 VIN.t5 VSS 0.22481f
C230 VIN.t0 VSS 0.22481f
C231 VIN.t2 VSS 0.2406f
C232 VIN.n13 VSS 0.19513f
C233 VIN.n14 VSS 0.02636f
C234 VIN.t12 VSS 0.22481f
C235 VIN.t4 VSS 0.22481f
C236 VIN.t3 VSS 0.2406f
C237 VIN.n15 VSS 0.19513f
C238 VIN.n16 VSS 0.02636f
C239 VIN.n17 VSS 0.06094f
C240 VIN.t9 VSS 0.00224f
C241 VIN.t7 VSS 0.00224f
C242 VIN.n18 VSS 0.00621f
C243 VIN.n19 VSS 0.0138f
C244 VIN.n20 VSS 0.0138f
C245 VIN.n21 VSS 0.02317f
C246 VIN.n22 VSS 0.04153f
C247 VIN.n23 VSS 0.01051f
C248 VIN.n24 VSS 0.09819f
C249 VIN.n25 VSS 0.04222f
C250 VIN.n26 VSS 0.05532f
C251 VIN.n27 VSS 0.05832f
C252 VIN.n28 VSS 0.10639f
C253 VIN.n29 VSS 0.14565f
C254 VIN.n30 VSS 0.02635f
C255 VIN.n31 VSS 0.11241f
C256 VIN.n32 VSS 0.01771f
C257 VIN.n33 VSS 0.00912f
C258 VIN.n34 VSS 0.00823f
C259 VIN.n35 VSS 0.02105f
C260 VIN.n36 VSS 0.02058f
C261 VIN.n37 VSS 0.02058f
C262 VIN.n38 VSS 0.0152f
C263 VIN.n39 VSS 0.02199f
C264 VIN.n40 VSS 0.0138f
C265 VIN.n41 VSS 0.02122f
C266 VIN.n42 VSS 0.02301f
C267 IBIAS_5uA.t5 VSS 0.07345f
C268 IBIAS_5uA.t3 VSS 0.07352f
C269 IBIAS_5uA.t2 VSS 0.16945f
C270 IBIAS_5uA.n0 VSS 0.24699f
C271 IBIAS_5uA.t11 VSS 0.16945f
C272 IBIAS_5uA.n1 VSS 0.11403f
C273 IBIAS_5uA.t9 VSS 0.16945f
C274 IBIAS_5uA.n2 VSS 0.11403f
C275 IBIAS_5uA.t0 VSS 0.16945f
C276 IBIAS_5uA.n3 VSS 0.08569f
C277 IBIAS_5uA.t1 VSS 0.01938f
C278 IBIAS_5uA.t7 VSS 0.01938f
C279 IBIAS_5uA.n4 VSS 0.03942f
C280 IBIAS_5uA.n5 VSS 0.2344f
C281 IBIAS_5uA.t6 VSS 0.16945f
C282 IBIAS_5uA.n6 VSS 0.08407f
C283 IBIAS_5uA.t8 VSS 0.16945f
C284 IBIAS_5uA.n7 VSS 0.11403f
C285 IBIAS_5uA.t10 VSS 0.16945f
C286 IBIAS_5uA.n8 VSS 0.11403f
C287 IBIAS_5uA.t4 VSS 0.16945f
C288 IBIAS_5uA.n9 VSS 0.09541f
C289 IBIAS_5uA.n10 VSS 0.42384f
.ends
