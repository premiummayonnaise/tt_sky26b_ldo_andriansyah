* NGSPICE file created from error-amplifier.ext - technology: sky130A

.subckt sky130_fd_pr__nfet_01v8_UX2DZA a_n207_n74# a_505_n74# a_n327_n129# a_327_n74#
+ a_385_n129# a_149_n74# a_n29_n74# a_n149_n129# a_207_n129# a_n741_n74# a_n563_n74#
+ a_n385_n74# a_683_n74# a_n843_n248# a_29_n129# a_n683_n129# a_n505_n129# a_563_n129#
X0 a_149_n74# a_29_n129# a_n29_n74# a_n843_n248# sky130_fd_pr__nfet_01v8 ad=0.15225 pd=1.34 as=0.15225 ps=1.34 w=1.05 l=0.6
X1 a_683_n74# a_563_n129# a_505_n74# a_n843_n248# sky130_fd_pr__nfet_01v8 ad=0.3045 pd=2.68 as=0.15225 ps=1.34 w=1.05 l=0.6
X2 a_n563_n74# a_n683_n129# a_n741_n74# a_n843_n248# sky130_fd_pr__nfet_01v8 ad=0.15225 pd=1.34 as=0.3045 ps=2.68 w=1.05 l=0.6
X3 a_327_n74# a_207_n129# a_149_n74# a_n843_n248# sky130_fd_pr__nfet_01v8 ad=0.15225 pd=1.34 as=0.15225 ps=1.34 w=1.05 l=0.6
X4 a_n207_n74# a_n327_n129# a_n385_n74# a_n843_n248# sky130_fd_pr__nfet_01v8 ad=0.15225 pd=1.34 as=0.15225 ps=1.34 w=1.05 l=0.6
X5 a_505_n74# a_385_n129# a_327_n74# a_n843_n248# sky130_fd_pr__nfet_01v8 ad=0.15225 pd=1.34 as=0.15225 ps=1.34 w=1.05 l=0.6
X6 a_n29_n74# a_n149_n129# a_n207_n74# a_n843_n248# sky130_fd_pr__nfet_01v8 ad=0.15225 pd=1.34 as=0.15225 ps=1.34 w=1.05 l=0.6
X7 a_n385_n74# a_n505_n129# a_n563_n74# a_n843_n248# sky130_fd_pr__nfet_01v8 ad=0.15225 pd=1.34 as=0.15225 ps=1.34 w=1.05 l=0.6
.ends

.subckt sky130_fd_pr__pfet_01v8_23YNHG a_n741_n736# a_n327_n762# a_385_n762# a_n563_n736#
+ a_683_n736# a_n149_n762# a_207_n762# w_n879_n884# a_n385_n736# a_505_n736# a_29_n762#
+ a_n683_n762# a_n207_n736# a_327_n736# a_n505_n762# a_n29_n736# a_563_n762# a_149_n736#
X0 a_n207_n736# a_n327_n762# a_n385_n736# w_n879_n884# sky130_fd_pr__pfet_01v8 ad=1.015 pd=7.29 as=1.015 ps=7.29 w=7 l=0.6
X1 a_683_n736# a_563_n762# a_505_n736# w_n879_n884# sky130_fd_pr__pfet_01v8 ad=2.03 pd=14.58 as=1.015 ps=7.29 w=7 l=0.6
X2 a_n29_n736# a_n149_n762# a_n207_n736# w_n879_n884# sky130_fd_pr__pfet_01v8 ad=1.015 pd=7.29 as=1.015 ps=7.29 w=7 l=0.6
X3 a_n563_n736# a_n683_n762# a_n741_n736# w_n879_n884# sky130_fd_pr__pfet_01v8 ad=1.015 pd=7.29 as=2.03 ps=14.58 w=7 l=0.6
X4 a_505_n736# a_385_n762# a_327_n736# w_n879_n884# sky130_fd_pr__pfet_01v8 ad=1.015 pd=7.29 as=1.015 ps=7.29 w=7 l=0.6
X5 a_n385_n736# a_n505_n762# a_n563_n736# w_n879_n884# sky130_fd_pr__pfet_01v8 ad=1.015 pd=7.29 as=1.015 ps=7.29 w=7 l=0.6
X6 a_327_n736# a_207_n762# a_149_n736# w_n879_n884# sky130_fd_pr__pfet_01v8 ad=1.015 pd=7.29 as=1.015 ps=7.29 w=7 l=0.6
X7 a_149_n736# a_29_n762# a_n29_n736# w_n879_n884# sky130_fd_pr__pfet_01v8 ad=1.015 pd=7.29 as=1.015 ps=7.29 w=7 l=0.6
.ends

.subckt sky130_fd_pr__pfet_01v8_ZYDSUC a_n385_n129# a_207_n226# w_n879_n349# a_505_n129#
+ a_n207_n129# a_29_n226# a_n683_n226# a_327_n129# a_n29_n129# a_149_n129# a_n505_n226#
+ a_563_n226# a_n741_n129# a_n327_n226# a_385_n226# a_n563_n129# a_683_n129# a_n149_n226#
X0 a_n385_n129# a_n505_n226# a_n563_n129# w_n879_n349# sky130_fd_pr__pfet_01v8 ad=0.23925 pd=1.94 as=0.23925 ps=1.94 w=1.65 l=0.6
X1 a_327_n129# a_207_n226# a_149_n129# w_n879_n349# sky130_fd_pr__pfet_01v8 ad=0.23925 pd=1.94 as=0.23925 ps=1.94 w=1.65 l=0.6
X2 a_149_n129# a_29_n226# a_n29_n129# w_n879_n349# sky130_fd_pr__pfet_01v8 ad=0.23925 pd=1.94 as=0.23925 ps=1.94 w=1.65 l=0.6
X3 a_n207_n129# a_n327_n226# a_n385_n129# w_n879_n349# sky130_fd_pr__pfet_01v8 ad=0.23925 pd=1.94 as=0.23925 ps=1.94 w=1.65 l=0.6
X4 a_683_n129# a_563_n226# a_505_n129# w_n879_n349# sky130_fd_pr__pfet_01v8 ad=0.4785 pd=3.88 as=0.23925 ps=1.94 w=1.65 l=0.6
X5 a_n29_n129# a_n149_n226# a_n207_n129# w_n879_n349# sky130_fd_pr__pfet_01v8 ad=0.23925 pd=1.94 as=0.23925 ps=1.94 w=1.65 l=0.6
X6 a_n563_n129# a_n683_n226# a_n741_n129# w_n879_n349# sky130_fd_pr__pfet_01v8 ad=0.23925 pd=1.94 as=0.4785 ps=3.88 w=1.65 l=0.6
X7 a_505_n129# a_385_n226# a_327_n129# w_n879_n349# sky130_fd_pr__pfet_01v8 ad=0.23925 pd=1.94 as=0.23925 ps=1.94 w=1.65 l=0.6
.ends

.subckt error-amplifier VIN VP VN IBIAS_5uA OUT VSS
XXM2 VSS VSS m1_1470_n1270# OUT m1_1470_n1270# VSS m1_1470_n1270# m1_1470_n1270# m1_1470_n1270#
+ m1_1470_n1270# VSS OUT m1_1470_n1270# VSS m1_1470_n1270# m1_1470_n1270# m1_1470_n1270#
+ m1_1470_n1270# sky130_fd_pr__nfet_01v8_UX2DZA
XXM3 m1_1470_n1270# VP VP m1_1680_n1060# m1_1470_n1270# VN VP VIN OUT m1_1680_n1060#
+ VN VN m1_1680_n1060# OUT VP m1_1470_n1270# VN m1_1680_n1060# sky130_fd_pr__pfet_01v8_23YNHG
XXM5 m1_1680_n1060# IBIAS_5uA VIN VIN VIN IBIAS_5uA IBIAS_5uA m1_1680_n1060# IBIAS_5uA
+ VIN IBIAS_5uA IBIAS_5uA IBIAS_5uA IBIAS_5uA IBIAS_5uA VIN IBIAS_5uA IBIAS_5uA sky130_fd_pr__pfet_01v8_ZYDSUC
.ends
