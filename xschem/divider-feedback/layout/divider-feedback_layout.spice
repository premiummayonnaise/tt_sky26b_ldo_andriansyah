* NGSPICE file created from divider-feedback.ext - technology: sky130A

.subckt sky130_fd_pr__res_xhigh_po_0p69_BG3BFW a_n69_674# a_n69_n1106# VSUBS
X0 a_n69_674# a_n69_n1106# VSUBS sky130_fd_pr__res_xhigh_po_0p69 l=6.9
.ends

.subckt divider-feedback VSS VDD VFB
Xsky130_fd_pr__res_xhigh_po_0p69_BG3BFW_11 m1_1500_3930# m1_1900_2672# VSS sky130_fd_pr__res_xhigh_po_0p69_BG3BFW
Xsky130_fd_pr__res_xhigh_po_0p69_BG3BFW_12 m1_2100_4280# m1_1700_2280# VSS sky130_fd_pr__res_xhigh_po_0p69_BG3BFW
Xsky130_fd_pr__res_xhigh_po_0p69_BG3BFW_14 m1_2100_4280# m1_2500_2280# VSS sky130_fd_pr__res_xhigh_po_0p69_BG3BFW
Xsky130_fd_pr__res_xhigh_po_0p69_BG3BFW_13 m1_2300_3930# m1_1900_2672# VSS sky130_fd_pr__res_xhigh_po_0p69_BG3BFW
Xsky130_fd_pr__res_xhigh_po_0p69_BG3BFW_15 m1_2300_3930# m1_2700_2672# VSS sky130_fd_pr__res_xhigh_po_0p69_BG3BFW
Xsky130_fd_pr__res_xhigh_po_0p69_BG3BFW_16 m1_2900_4280# m1_2500_2280# VSS sky130_fd_pr__res_xhigh_po_0p69_BG3BFW
Xsky130_fd_pr__res_xhigh_po_0p69_BG3BFW_17 m1_3100_3930# m1_2700_2672# VSS sky130_fd_pr__res_xhigh_po_0p69_BG3BFW
Xsky130_fd_pr__res_xhigh_po_0p69_BG3BFW_18 m1_2900_4280# VFB VSS sky130_fd_pr__res_xhigh_po_0p69_BG3BFW
Xsky130_fd_pr__res_xhigh_po_0p69_BG3BFW_19 m1_3100_3930# VDD VSS sky130_fd_pr__res_xhigh_po_0p69_BG3BFW
XXR5 m1_n300_4394# VSS VSS sky130_fd_pr__res_xhigh_po_0p69_BG3BFW
Xsky130_fd_pr__res_xhigh_po_0p69_BG3BFW_0 m1_n100_3930# VFB VSS sky130_fd_pr__res_xhigh_po_0p69_BG3BFW
Xsky130_fd_pr__res_xhigh_po_0p69_BG3BFW_1 m1_n300_4394# m1_100_2280# VSS sky130_fd_pr__res_xhigh_po_0p69_BG3BFW
Xsky130_fd_pr__res_xhigh_po_0p69_BG3BFW_2 VSS VSS VSS sky130_fd_pr__res_xhigh_po_0p69_BG3BFW
Xsky130_fd_pr__res_xhigh_po_0p69_BG3BFW_3 m1_n100_3930# m1_300_2672# VSS sky130_fd_pr__res_xhigh_po_0p69_BG3BFW
Xsky130_fd_pr__res_xhigh_po_0p69_BG3BFW_4 m1_500_4280# m1_100_2280# VSS sky130_fd_pr__res_xhigh_po_0p69_BG3BFW
Xsky130_fd_pr__res_xhigh_po_0p69_BG3BFW_5 m1_700_3930# m1_300_2672# VSS sky130_fd_pr__res_xhigh_po_0p69_BG3BFW
Xsky130_fd_pr__res_xhigh_po_0p69_BG3BFW_6 m1_500_4280# m1_900_2280# VSS sky130_fd_pr__res_xhigh_po_0p69_BG3BFW
Xsky130_fd_pr__res_xhigh_po_0p69_BG3BFW_8 m1_1300_4280# m1_900_2280# VSS sky130_fd_pr__res_xhigh_po_0p69_BG3BFW
Xsky130_fd_pr__res_xhigh_po_0p69_BG3BFW_7 m1_700_3930# m1_1100_2672# VSS sky130_fd_pr__res_xhigh_po_0p69_BG3BFW
Xsky130_fd_pr__res_xhigh_po_0p69_BG3BFW_9 m1_1500_3930# m1_1100_2672# VSS sky130_fd_pr__res_xhigh_po_0p69_BG3BFW
Xsky130_fd_pr__res_xhigh_po_0p69_BG3BFW_20 VSS VSS VSS sky130_fd_pr__res_xhigh_po_0p69_BG3BFW
Xsky130_fd_pr__res_xhigh_po_0p69_BG3BFW_10 m1_1300_4280# m1_1700_2280# VSS sky130_fd_pr__res_xhigh_po_0p69_BG3BFW
.ends
