** sch_path: /foss/designs/2026/tt_sky26b_ldo_andriansyah/xschem/bias-net/schematics/bias-network.sch
.subckt bias-network VDD IBIAS1 IBIAS2 VREF VSS
*.PININFO VDD:B VSS:B IBIAS1:O IBIAS2:O VREF:O
XM2 VREF VREF VSS VSS sky130_fd_pr__nfet_01v8 L=2 W=3 nf=4 m=2
XR1 VREF net1 VSS sky130_fd_pr__res_xhigh_po_0p69 L=6.9 mult=1 m=1
XR2 net2 net1 VSS sky130_fd_pr__res_xhigh_po_0p69 L=6.9 mult=1 m=1
XR3 net2 net3 VSS sky130_fd_pr__res_xhigh_po_0p69 L=6.9 mult=1 m=1
XR4 net4 net3 VSS sky130_fd_pr__res_xhigh_po_0p69 L=6.9 mult=1 m=1
XR5 net4 net5 VSS sky130_fd_pr__res_xhigh_po_0p69 L=6.9 mult=1 m=1
XR6 net9 net10 VSS sky130_fd_pr__res_xhigh_po_0p69 L=6.9 mult=1 m=1
XR7 net9 net8 VSS sky130_fd_pr__res_xhigh_po_0p69 L=6.9 mult=1 m=1
XR8 net7 net8 VSS sky130_fd_pr__res_xhigh_po_0p69 L=6.9 mult=1 m=1
XR9 net7 net6 VSS sky130_fd_pr__res_xhigh_po_0p69 L=6.9 mult=1 m=1
XR10 net5 net6 VSS sky130_fd_pr__res_xhigh_po_0p69 L=6.9 mult=1 m=1
XM1 IBIAS1 VREF VSS VSS sky130_fd_pr__nfet_01v8 L=2 W=3 nf=4 m=2
XM3 IBIAS2 VREF VSS VSS sky130_fd_pr__nfet_01v8 L=2 W=3 nf=4 m=2
XR11 net10 net11 VSS sky130_fd_pr__res_xhigh_po_0p69 L=6.9 mult=1 m=1
XR12 net12 net11 VSS sky130_fd_pr__res_xhigh_po_0p69 L=6.9 mult=1 m=1
XR13 net12 net13 VSS sky130_fd_pr__res_xhigh_po_0p69 L=6.9 mult=1 m=1
XR14 net14 net13 VSS sky130_fd_pr__res_xhigh_po_0p69 L=6.9 mult=1 m=1
XR15 net14 net15 VSS sky130_fd_pr__res_xhigh_po_0p69 L=6.9 mult=1 m=1
XR16 net19 VDD VSS sky130_fd_pr__res_xhigh_po_0p69 L=6.9 mult=1 m=1
XR17 net19 net18 VSS sky130_fd_pr__res_xhigh_po_0p69 L=6.9 mult=1 m=1
XR18 net17 net18 VSS sky130_fd_pr__res_xhigh_po_0p69 L=6.9 mult=1 m=1
XR19 net17 net16 VSS sky130_fd_pr__res_xhigh_po_0p69 L=6.9 mult=1 m=1
XR20 net15 net16 VSS sky130_fd_pr__res_xhigh_po_0p69 L=6.9 mult=1 m=1
XR21 VSS VSS VSS sky130_fd_pr__res_xhigh_po_0p69 L=6.9 mult=1 m=1
XR22 VSS VSS VSS sky130_fd_pr__res_xhigh_po_0p69 L=6.9 mult=1 m=1
.ends
