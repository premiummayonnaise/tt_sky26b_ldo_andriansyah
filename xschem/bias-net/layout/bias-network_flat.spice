* NGSPICE file created from bias-network_flat.ext - technology: sky130A

.subckt bias-network_flat VREF IBIAS1 IBIAS2 VDD VSS
X0 a_4162_3368# a_4362_1588# VSS.t13 sky130_fd_pr__res_xhigh_po_0p69 l=6.9
X1 VSS.t6 VREF.t17 IBIAS2.t7 VSS.t0 sky130_fd_pr__nfet_01v8 ad=0.10875 pd=1.04 as=0.2175 ps=2.08 w=0.75 l=2
X2 VSS.t10 VREF.t18 IBIAS2.t6 VSS.t0 sky130_fd_pr__nfet_01v8 ad=0.10875 pd=1.04 as=0.2175 ps=2.08 w=0.75 l=2
X3 a_4562_3368# a_4762_1588# VSS.t57 sky130_fd_pr__res_xhigh_po_0p69 l=6.9
X4 a_3362_3368# a_3162_1588# VSS.t24 sky130_fd_pr__res_xhigh_po_0p69 l=6.9
X5 IBIAS2.t5 VREF.t19 VSS.t39 VSS.t8 sky130_fd_pr__nfet_01v8 ad=0.10875 pd=1.04 as=0.10875 ps=1.04 w=0.75 l=2
X6 IBIAS2.t4 VREF.t20 VSS.t32 VSS.t8 sky130_fd_pr__nfet_01v8 ad=0.10875 pd=1.04 as=0.10875 ps=1.04 w=0.75 l=2
X7 VSS.t53 VREF.t14 VREF.t15 VSS.t40 sky130_fd_pr__nfet_01v8 ad=0.10875 pd=1.04 as=0.2175 ps=2.08 w=0.75 l=2
X8 a_3762_3368# a_3562_1588# VSS.t30 sky130_fd_pr__res_xhigh_po_0p69 l=6.9
X9 IBIAS1.t7 VREF.t21 VSS.t56 VSS.t20 sky130_fd_pr__nfet_01v8 ad=0.2175 pd=2.08 as=0.10875 ps=1.04 w=0.75 l=2
X10 IBIAS1.t6 VREF.t22 VSS.t21 VSS.t20 sky130_fd_pr__nfet_01v8 ad=0.2175 pd=2.08 as=0.10875 ps=1.04 w=0.75 l=2
X11 VREF.t13 VREF.t12 VSS.t27 VSS.t26 sky130_fd_pr__nfet_01v8 ad=0.10875 pd=1.04 as=0.10875 ps=1.04 w=0.75 l=2
X12 VREF.t11 VREF.t10 VSS.t37 VSS.t36 sky130_fd_pr__nfet_01v8 ad=0.2175 pd=2.08 as=0.10875 ps=1.04 w=0.75 l=2
X13 a_6162_3368# a_5962_1588# VSS.t51 sky130_fd_pr__res_xhigh_po_0p69 l=6.9
X14 VSS.t49 VREF.t23 IBIAS1.t5 VSS.t4 sky130_fd_pr__nfet_01v8 ad=0.10875 pd=1.04 as=0.10875 ps=1.04 w=0.75 l=2
X15 VSS.t52 VREF.t24 IBIAS1.t4 VSS.t4 sky130_fd_pr__nfet_01v8 ad=0.10875 pd=1.04 as=0.10875 ps=1.04 w=0.75 l=2
X16 VSS.t41 VREF.t8 VREF.t9 VSS.t40 sky130_fd_pr__nfet_01v8 ad=0.10875 pd=1.04 as=0.2175 ps=2.08 w=0.75 l=2
X17 a_6562_3368# a_6362_1588# VSS.t19 sky130_fd_pr__res_xhigh_po_0p69 l=6.9
X18 VREF.t16 a_6762_1588# VSS.t54 sky130_fd_pr__res_xhigh_po_0p69 l=6.9
X19 VSS.t46 VSS.t47 VSS.t45 sky130_fd_pr__res_xhigh_po_0p69 l=6.9
X20 a_4962_3368# a_5162_1588# VSS.t15 sky130_fd_pr__res_xhigh_po_0p69 l=6.9
X21 IBIAS2.t3 VREF.t25 VSS.t55 VSS.t20 sky130_fd_pr__nfet_01v8 ad=0.2175 pd=2.08 as=0.10875 ps=1.04 w=0.75 l=2
X22 VSS.t22 VREF.t6 VREF.t7 VSS.t11 sky130_fd_pr__nfet_01v8 ad=0.10875 pd=1.04 as=0.10875 ps=1.04 w=0.75 l=2
X23 a_5362_3368# a_5562_1588# VSS.t50 sky130_fd_pr__res_xhigh_po_0p69 l=6.9
X24 IBIAS2.t2 VREF.t26 VSS.t25 VSS.t20 sky130_fd_pr__nfet_01v8 ad=0.2175 pd=2.08 as=0.10875 ps=1.04 w=0.75 l=2
X25 a_5762_3368# a_5962_1588# VSS.t2 sky130_fd_pr__res_xhigh_po_0p69 l=6.9
X26 VREF.t5 VREF.t4 VSS.t42 VSS.t36 sky130_fd_pr__nfet_01v8 ad=0.2175 pd=2.08 as=0.10875 ps=1.04 w=0.75 l=2
X27 a_4162_3368# a_3962_1588# VSS.t29 sky130_fd_pr__res_xhigh_po_0p69 l=6.9
X28 a_4562_3368# a_4362_1588# VSS.t35 sky130_fd_pr__res_xhigh_po_0p69 l=6.9
X29 a_4962_3368# a_4762_1588# VSS.t7 sky130_fd_pr__res_xhigh_po_0p69 l=6.9
X30 VDD.t0 a_3162_1588# VSS.t34 sky130_fd_pr__res_xhigh_po_0p69 l=6.9
X31 VSS.t48 VREF.t27 IBIAS2.t1 VSS.t4 sky130_fd_pr__nfet_01v8 ad=0.10875 pd=1.04 as=0.10875 ps=1.04 w=0.75 l=2
X32 VSS.t5 VREF.t28 IBIAS2.t0 VSS.t4 sky130_fd_pr__nfet_01v8 ad=0.10875 pd=1.04 as=0.10875 ps=1.04 w=0.75 l=2
X33 a_3362_3368# a_3562_1588# VSS.t31 sky130_fd_pr__res_xhigh_po_0p69 l=6.9
X34 a_3762_3368# a_3962_1588# VSS.t43 sky130_fd_pr__res_xhigh_po_0p69 l=6.9
X35 VSS.t17 VSS.t18 VSS.t16 sky130_fd_pr__res_xhigh_po_0p69 l=6.9
X36 VSS.t12 VREF.t2 VREF.t3 VSS.t11 sky130_fd_pr__nfet_01v8 ad=0.10875 pd=1.04 as=0.10875 ps=1.04 w=0.75 l=2
X37 VSS.t1 VREF.t29 IBIAS1.t3 VSS.t0 sky130_fd_pr__nfet_01v8 ad=0.10875 pd=1.04 as=0.2175 ps=2.08 w=0.75 l=2
X38 VSS.t3 VREF.t30 IBIAS1.t2 VSS.t0 sky130_fd_pr__nfet_01v8 ad=0.10875 pd=1.04 as=0.2175 ps=2.08 w=0.75 l=2
X39 IBIAS1.t1 VREF.t31 VSS.t9 VSS.t8 sky130_fd_pr__nfet_01v8 ad=0.10875 pd=1.04 as=0.10875 ps=1.04 w=0.75 l=2
X40 IBIAS1.t0 VREF.t32 VSS.t28 VSS.t8 sky130_fd_pr__nfet_01v8 ad=0.10875 pd=1.04 as=0.10875 ps=1.04 w=0.75 l=2
X41 a_6162_3368# a_6362_1588# VSS.t23 sky130_fd_pr__res_xhigh_po_0p69 l=6.9
X42 a_6562_3368# a_6762_1588# VSS.t44 sky130_fd_pr__res_xhigh_po_0p69 l=6.9
X43 VREF.t1 VREF.t0 VSS.t38 VSS.t26 sky130_fd_pr__nfet_01v8 ad=0.10875 pd=1.04 as=0.10875 ps=1.04 w=0.75 l=2
X44 a_5362_3368# a_5162_1588# VSS.t14 sky130_fd_pr__res_xhigh_po_0p69 l=6.9
X45 a_5762_3368# a_5562_1588# VSS.t33 sky130_fd_pr__res_xhigh_po_0p69 l=6.9
R0 VSS.n50 VSS.n4 7495.85
R1 VSS.n50 VSS.n5 7495.85
R2 VSS.n47 VSS.n4 7476.15
R3 VSS.n47 VSS.n5 7476.15
R4 VSS.n38 VSS.n7 4826.5
R5 VSS.n38 VSS.n2 4826.5
R6 VSS.n6 VSS.n2 4826.5
R7 VSS.n7 VSS.n6 4826.5
R8 VSS.t20 VSS.t11 597.255
R9 VSS.t40 VSS.t8 597.255
R10 VSS.n7 VSS.t36 586.003
R11 VSS.n40 VSS.t0 509.308
R12 VSS.t45 VSS.n47 433.736
R13 VSS.n49 VSS.t16 368.854
R14 VSS.t34 VSS.t45 343.914
R15 VSS.t26 VSS.n39 329.476
R16 VSS.t16 VSS.t54 312.411
R17 VSS.n44 VSS.n43 269.44
R18 VSS.n41 VSS.n0 269.44
R19 VSS.n39 VSS.t4 267.781
R20 VSS.n45 VSS.n44 263.296
R21 VSS.n42 VSS.n41 263.296
R22 VSS.n49 VSS.n40 262.531
R23 VSS.t54 VSS.t44 262.531
R24 VSS.t44 VSS.t19 262.531
R25 VSS.t19 VSS.t23 262.531
R26 VSS.t23 VSS.t51 262.531
R27 VSS.t51 VSS.t2 262.531
R28 VSS.t2 VSS.t33 262.531
R29 VSS.t33 VSS.t50 262.531
R30 VSS.t50 VSS.t14 262.531
R31 VSS.t14 VSS.t15 262.531
R32 VSS.t7 VSS.t57 262.531
R33 VSS.t57 VSS.t35 262.531
R34 VSS.t35 VSS.t13 262.531
R35 VSS.t13 VSS.t29 262.531
R36 VSS.t29 VSS.t43 262.531
R37 VSS.t43 VSS.t30 262.531
R38 VSS.t30 VSS.t31 262.531
R39 VSS.t31 VSS.t24 262.531
R40 VSS.t24 VSS.t34 262.531
R41 VSS.n35 VSS.n34 257.664
R42 VSS.n36 VSS.n35 257.664
R43 VSS.n46 VSS.n45 204.8
R44 VSS.n46 VSS.n42 204.8
R45 VSS.t15 VSS.n48 178.52
R46 VSS.n13 VSS.n11 126.105
R47 VSS.n25 VSS.n23 126.105
R48 VSS.n17 VSS.n15 122.075
R49 VSS.n29 VSS.n27 122.075
R50 VSS.n19 VSS.n18 92.5005
R51 VSS.n17 VSS.n16 92.5005
R52 VSS.n15 VSS.n14 92.5005
R53 VSS.n13 VSS.n12 92.5005
R54 VSS.n11 VSS.n10 92.5005
R55 VSS.n9 VSS.n8 92.5005
R56 VSS.n31 VSS.n30 92.5005
R57 VSS.n29 VSS.n28 92.5005
R58 VSS.n27 VSS.n26 92.5005
R59 VSS.n25 VSS.n24 92.5005
R60 VSS.n23 VSS.n22 92.5005
R61 VSS.n21 VSS.n20 92.5005
R62 VSS.n11 VSS.n9 87.2301
R63 VSS.n15 VSS.n13 87.2301
R64 VSS.n19 VSS.n17 87.2301
R65 VSS.n23 VSS.n21 87.2301
R66 VSS.n27 VSS.n25 87.2301
R67 VSS.n31 VSS.n29 87.2301
R68 VSS.n48 VSS.t7 84.01
R69 VSS.n32 VSS.n3 72.8325
R70 VSS.n52 VSS.n1 72.8325
R71 VSS.n34 VSS.n19 66.3709
R72 VSS.n32 VSS.n31 66.3709
R73 VSS.n36 VSS.n9 63.7635
R74 VSS.n21 VSS.n1 63.7635
R75 VSS.n42 VSS.t46 62.9068
R76 VSS.n0 VSS.t17 62.9068
R77 VSS.n33 VSS.n32 61.5685
R78 VSS.n37 VSS.n1 61.5685
R79 VSS.n52 VSS.n51 59.7338
R80 VSS.n51 VSS.n3 59.7338
R81 VSS.n34 VSS.n33 55.9365
R82 VSS.n37 VSS.n36 55.9365
R83 VSS.n43 VSS.t18 53.2624
R84 VSS.n45 VSS.t47 53.2624
R85 VSS.n8 VSS.t25 23.2005
R86 VSS.n8 VSS.t48 23.2005
R87 VSS.n10 VSS.t55 23.2005
R88 VSS.n10 VSS.t5 23.2005
R89 VSS.n12 VSS.t56 23.2005
R90 VSS.n12 VSS.t49 23.2005
R91 VSS.n14 VSS.t21 23.2005
R92 VSS.n14 VSS.t52 23.2005
R93 VSS.n16 VSS.t42 23.2005
R94 VSS.n16 VSS.t12 23.2005
R95 VSS.n18 VSS.t37 23.2005
R96 VSS.n18 VSS.t22 23.2005
R97 VSS.n20 VSS.t39 23.2005
R98 VSS.n20 VSS.t6 23.2005
R99 VSS.n22 VSS.t32 23.2005
R100 VSS.n22 VSS.t10 23.2005
R101 VSS.n24 VSS.t9 23.2005
R102 VSS.n24 VSS.t3 23.2005
R103 VSS.n26 VSS.t28 23.2005
R104 VSS.n26 VSS.t1 23.2005
R105 VSS.n28 VSS.t27 23.2005
R106 VSS.n28 VSS.t41 23.2005
R107 VSS.n30 VSS.t38 23.2005
R108 VSS.n30 VSS.t53 23.2005
R109 VSS.n43 VSS.n3 20.7365
R110 VSS.n52 VSS.n0 20.7365
R111 VSS.n33 VSS.n6 19.5005
R112 VSS.n39 VSS.n6 19.5005
R113 VSS.n38 VSS.n37 19.5005
R114 VSS.n39 VSS.n38 19.5005
R115 VSS.n35 VSS.n7 15.0005
R116 VSS.n47 VSS.n46 15.0005
R117 VSS.n51 VSS.n2 15.0005
R118 VSS.n40 VSS.n2 15.0005
R119 VSS.n51 VSS.n50 15.0005
R120 VSS.n50 VSS.n49 15.0005
R121 VSS VSS.n52 10.6918
R122 VSS.n44 VSS.n5 8.35764
R123 VSS.n48 VSS.n5 8.35764
R124 VSS.n41 VSS.n4 8.35764
R125 VSS.n48 VSS.n4 8.35764
R126 VSS.t36 VSS.t20 3.93845
R127 VSS.t11 VSS.t4 3.93845
R128 VSS.t8 VSS.t26 3.93845
R129 VSS.t0 VSS.t40 3.93845
R130 VREF.n23 VREF.t5 120.35
R131 VREF.n20 VREF.t11 120.35
R132 VREF.n1 VREF.t9 120.35
R133 VREF.n48 VREF.t15 120.35
R134 VREF.n13 VREF.n12 97.1505
R135 VREF.n27 VREF.n26 97.1505
R136 VREF.n16 VREF.t10 26.8475
R137 VREF.n24 VREF.t4 26.8475
R138 VREF.n29 VREF.t22 26.8475
R139 VREF.n30 VREF.t21 26.8475
R140 VREF.n31 VREF.t25 26.8475
R141 VREF.n32 VREF.t26 26.8475
R142 VREF.n43 VREF.t6 26.8475
R143 VREF.n40 VREF.t2 26.8475
R144 VREF.n37 VREF.t24 26.8475
R145 VREF.n36 VREF.t23 26.8475
R146 VREF.n35 VREF.t28 26.8475
R147 VREF.n34 VREF.t27 26.8475
R148 VREF.n46 VREF.t0 26.8475
R149 VREF.n7 VREF.t12 26.8475
R150 VREF.n5 VREF.t32 26.8475
R151 VREF.n4 VREF.t31 26.8475
R152 VREF.n3 VREF.t20 26.8475
R153 VREF.n2 VREF.t19 26.8475
R154 VREF.n50 VREF.t14 26.8475
R155 VREF.n53 VREF.t8 26.8475
R156 VREF.n55 VREF.t29 26.8475
R157 VREF.n56 VREF.t30 26.8475
R158 VREF.n57 VREF.t18 26.8475
R159 VREF.n58 VREF.t17 26.8475
R160 VREF.n12 VREF.t7 23.2005
R161 VREF.n12 VREF.t1 23.2005
R162 VREF.n26 VREF.t3 23.2005
R163 VREF.n26 VREF.t13 23.2005
R164 VREF.n60 VREF.t16 22.4056
R165 VREF VREF.n60 3.46465
R166 VREF.n52 VREF.n8 0.6255
R167 VREF.n51 VREF.n10 0.6255
R168 VREF.n41 VREF.n19 0.6255
R169 VREF.n42 VREF.n17 0.6255
R170 VREF.n49 VREF.n47 0.556056
R171 VREF.n54 VREF.n6 0.556056
R172 VREF.n44 VREF.n14 0.556013
R173 VREF.n39 VREF.n25 0.556013
R174 VREF.n25 VREF.n23 0.513671
R175 VREF.n20 VREF.n14 0.513671
R176 VREF.n49 VREF.n48 0.499782
R177 VREF.n54 VREF.n1 0.499782
R178 VREF.n33 VREF.n32 0.424827
R179 VREF.n60 VREF.n59 0.366066
R180 VREF.n31 VREF.n30 0.30357
R181 VREF.n36 VREF.n35 0.30357
R182 VREF.n4 VREF.n3 0.30357
R183 VREF.n57 VREF.n56 0.30357
R184 VREF.n59 VREF.n0 0.283519
R185 VREF.n45 VREF.n13 0.28175
R186 VREF.n28 VREF.n27 0.28175
R187 VREF.n23 VREF.n22 0.280672
R188 VREF.n21 VREF.n20 0.280672
R189 VREF.n9 VREF.n1 0.280672
R190 VREF.n48 VREF.n11 0.280672
R191 VREF.n33 VREF.n0 0.271726
R192 VREF.n15 VREF.n13 0.271333
R193 VREF.n27 VREF.n18 0.271333
R194 VREF.n21 VREF.n17 0.2505
R195 VREF.n22 VREF.n19 0.2505
R196 VREF.n52 VREF.n9 0.234875
R197 VREF.n51 VREF.n11 0.234875
R198 VREF.n22 VREF.n21 0.233259
R199 VREF.n11 VREF.n9 0.233259
R200 VREF.n15 VREF.n10 0.229667
R201 VREF.n18 VREF.n8 0.229667
R202 VREF.n29 VREF.n25 0.216808
R203 VREF.n38 VREF.n37 0.216808
R204 VREF.n6 VREF.n5 0.216808
R205 VREF.n55 VREF.n54 0.216808
R206 VREF.n42 VREF.n15 0.214042
R207 VREF.n41 VREF.n18 0.214042
R208 VREF.n32 VREF.n31 0.210388
R209 VREF.n30 VREF.n29 0.210388
R210 VREF.n35 VREF.n34 0.210388
R211 VREF.n37 VREF.n36 0.210388
R212 VREF.n3 VREF.n2 0.210388
R213 VREF.n5 VREF.n4 0.210388
R214 VREF.n58 VREF.n57 0.210388
R215 VREF.n56 VREF.n55 0.210388
R216 VREF.n47 VREF.n45 0.204204
R217 VREF.n28 VREF.n6 0.204204
R218 VREF.n45 VREF.n44 0.190315
R219 VREF.n38 VREF.n28 0.190315
R220 VREF.n34 VREF.n33 0.141808
R221 VREF.n2 VREF.n0 0.141808
R222 VREF.n59 VREF.n58 0.141808
R223 VREF.n25 VREF.n24 0.0776032
R224 VREF.n16 VREF.n14 0.0776032
R225 VREF.n44 VREF.n43 0.0776032
R226 VREF.n7 VREF.n6 0.0776032
R227 VREF.n47 VREF.n46 0.0776032
R228 VREF.n54 VREF.n53 0.0776032
R229 VREF.n50 VREF.n49 0.0776032
R230 VREF.n40 VREF.n39 0.077035
R231 VREF.n51 VREF.n50 0.0747623
R232 VREF.n46 VREF.n10 0.0747623
R233 VREF.n43 VREF.n42 0.0747623
R234 VREF.n17 VREF.n16 0.0747623
R235 VREF.n24 VREF.n19 0.0747623
R236 VREF.n41 VREF.n40 0.0747623
R237 VREF.n8 VREF.n7 0.0747623
R238 VREF.n53 VREF.n52 0.0747623
R239 VREF.n19 VREF.n17 0.0618636
R240 VREF.n42 VREF.n41 0.0618636
R241 VREF.n10 VREF.n8 0.0618636
R242 VREF.n52 VREF.n51 0.0618636
R243 VREF.n39 VREF.n38 0.00106818
R244 IBIAS2.n0 IBIAS2.t7 120.692
R245 IBIAS2.n5 IBIAS2.t2 120.692
R246 IBIAS2.n0 IBIAS2.t6 120.477
R247 IBIAS2.n5 IBIAS2.t3 120.477
R248 IBIAS2.n3 IBIAS2.n2 97.492
R249 IBIAS2.n3 IBIAS2.n1 97.2768
R250 IBIAS2.n2 IBIAS2.t1 23.2005
R251 IBIAS2.n2 IBIAS2.t5 23.2005
R252 IBIAS2.n1 IBIAS2.t0 23.2005
R253 IBIAS2.n1 IBIAS2.t4 23.2005
R254 IBIAS2.n4 IBIAS2.n0 2.22599
R255 IBIAS2.n6 IBIAS2.n4 1.46479
R256 IBIAS2.n4 IBIAS2.n3 0.7617
R257 IBIAS2.n6 IBIAS2.n5 0.7617
R258 IBIAS2 IBIAS2.n6 0.464786
R259 IBIAS1.n0 IBIAS1.t2 120.68
R260 IBIAS1.n5 IBIAS1.t7 120.68
R261 IBIAS1.n0 IBIAS1.t3 120.487
R262 IBIAS1.n5 IBIAS1.t6 120.487
R263 IBIAS1.n3 IBIAS1.n2 97.4808
R264 IBIAS1.n3 IBIAS1.n1 97.2868
R265 IBIAS1.n2 IBIAS1.t5 23.2005
R266 IBIAS1.n2 IBIAS1.t1 23.2005
R267 IBIAS1.n1 IBIAS1.t4 23.2005
R268 IBIAS1.n1 IBIAS1.t0 23.2005
R269 IBIAS1.n4 IBIAS1.n0 2.21747
R270 IBIAS1.n6 IBIAS1.n4 1.46479
R271 IBIAS1.n4 IBIAS1.n3 0.753184
R272 IBIAS1.n6 IBIAS1.n5 0.753184
R273 IBIAS1 IBIAS1.n6 0.464786
R274 VDD VDD.t0 22.0257
C0 a_5362_3368# a_5562_1588# 0.00697f
C1 a_5962_1588# a_6162_3368# 0.00697f
C2 a_3962_1588# a_3562_1588# 0.4184f
C3 a_4762_1588# a_4562_3368# 0.00697f
C4 a_3162_1588# a_3362_3368# 0.00697f
C5 a_4962_3368# a_5362_3368# 0.4184f
C6 a_6362_1588# a_6162_3368# 0.00697f
C7 a_3762_3368# a_3362_3368# 0.4184f
C8 a_6562_3368# a_6362_1588# 0.00697f
C9 a_5762_3368# a_6162_3368# 0.4184f
C10 IBIAS1 IBIAS2 0.28073f
C11 a_6762_1588# a_6562_3368# 0.00697f
C12 a_5162_1588# a_5562_1588# 0.4184f
C13 a_5962_1588# a_5562_1588# 0.4184f
C14 a_3962_1588# a_4162_3368# 0.00697f
C15 a_5162_1588# a_4962_3368# 0.00697f
C16 a_4362_1588# a_4562_3368# 0.00697f
C17 a_4762_1588# a_4362_1588# 0.4184f
C18 a_6562_3368# a_6162_3368# 0.4184f
C19 a_5762_3368# a_5562_1588# 0.00697f
C20 a_4962_3368# a_4562_3368# 0.4184f
C21 a_4962_3368# a_4762_1588# 0.00697f
C22 a_3562_1588# a_3362_3368# 0.00697f
C23 a_3162_1588# a_3562_1588# 0.4184f
C24 a_5162_1588# a_5362_3368# 0.00697f
C25 a_3762_3368# a_3562_1588# 0.00697f
C26 a_5962_1588# VREF 0.00109f
C27 a_5762_3368# a_5362_3368# 0.4184f
C28 a_3962_1588# a_3762_3368# 0.00697f
C29 a_4162_3368# a_4562_3368# 0.4184f
C30 VREF a_6362_1588# 0.00244f
C31 VDD a_3362_3368# 0.42143f
C32 IBIAS1 VREF 3.19228f
C33 VDD a_3162_1588# 0.00697f
C34 VREF a_5762_3368# 0
C35 a_4162_3368# a_3762_3368# 0.4184f
C36 VREF a_6762_1588# 0.01439f
C37 a_5962_1588# a_6362_1588# 0.4184f
C38 a_3962_1588# a_4362_1588# 0.4184f
C39 a_5962_1588# a_5762_3368# 0.00697f
C40 VREF a_6162_3368# 0.00162f
C41 a_5162_1588# a_4762_1588# 0.4184f
C42 a_6762_1588# a_6362_1588# 0.4184f
C43 a_4162_3368# a_4362_1588# 0.00697f
C44 VREF a_6562_3368# 0.42214f
C45 VREF IBIAS2 3.09076f
C46 IBIAS1 VSS 2.03548f
C47 IBIAS2 VSS 2.04164f
C48 VREF VSS 26.61486f
C49 VDD VSS 0.95675f
C50 a_6762_1588# VSS 0.73953f
C51 a_6562_3368# VSS 0.42639f
C52 a_6362_1588# VSS 0.42713f
C53 a_6162_3368# VSS 0.42639f
C54 a_5962_1588# VSS 0.42713f
C55 a_5762_3368# VSS 0.42639f
C56 a_5562_1588# VSS 0.42713f
C57 a_5362_3368# VSS 0.42639f
C58 a_5162_1588# VSS 0.42713f
C59 a_4962_3368# VSS 0.42639f
C60 a_4762_1588# VSS 0.42713f
C61 a_4562_3368# VSS 0.42639f
C62 a_4362_1588# VSS 0.42713f
C63 a_4162_3368# VSS 0.42639f
C64 a_3962_1588# VSS 0.42713f
C65 a_3762_3368# VSS 0.42639f
C66 a_3562_1588# VSS 0.42713f
C67 a_3362_3368# VSS 0.42356f
C68 a_3162_1588# VSS 0.70815f
C69 IBIAS1.t3 VSS 0.03638f
C70 IBIAS1.t2 VSS 0.03663f
C71 IBIAS1.n0 VSS 0.71141f
C72 IBIAS1.t4 VSS 0.01028f
C73 IBIAS1.t0 VSS 0.01028f
C74 IBIAS1.n1 VSS 0.02204f
C75 IBIAS1.t5 VSS 0.01028f
C76 IBIAS1.t1 VSS 0.01028f
C77 IBIAS1.n2 VSS 0.02234f
C78 IBIAS1.n3 VSS 0.46092f
C79 IBIAS1.n4 VSS 0.61831f
C80 IBIAS1.t6 VSS 0.03638f
C81 IBIAS1.t7 VSS 0.03663f
C82 IBIAS1.n5 VSS 0.47342f
C83 IBIAS1.n6 VSS 0.40334f
C84 IBIAS2.t6 VSS 0.03523f
C85 IBIAS2.t7 VSS 0.03547f
C86 IBIAS2.n0 VSS 0.68776f
C87 IBIAS2.t0 VSS 0.00996f
C88 IBIAS2.t4 VSS 0.00996f
C89 IBIAS2.n1 VSS 0.02134f
C90 IBIAS2.t1 VSS 0.00996f
C91 IBIAS2.t5 VSS 0.00996f
C92 IBIAS2.n2 VSS 0.02162f
C93 IBIAS2.n3 VSS 0.44492f
C94 IBIAS2.n4 VSS 0.60206f
C95 IBIAS2.t3 VSS 0.03523f
C96 IBIAS2.t2 VSS 0.03547f
C97 IBIAS2.n5 VSS 0.45702f
C98 IBIAS2.n6 VSS 0.39236f
C99 VREF.t16 VSS 0.02618f
C100 VREF.n0 VSS 0.06978f
C101 VREF.t9 VSS 0.00711f
C102 VREF.n1 VSS 0.01619f
C103 VREF.t19 VSS 0.11076f
C104 VREF.n2 VSS 0.06548f
C105 VREF.t20 VSS 0.11076f
C106 VREF.n3 VSS 0.10493f
C107 VREF.t31 VSS 0.11076f
C108 VREF.n4 VSS 0.10493f
C109 VREF.t32 VSS 0.11076f
C110 VREF.n5 VSS 0.08256f
C111 VREF.n6 VSS 0.08675f
C112 VREF.t12 VSS 0.11076f
C113 VREF.n7 VSS 0.00124f
C114 VREF.n8 VSS 0.0514f
C115 VREF.n9 VSS 0.00843f
C116 VREF.n10 VSS 0.0514f
C117 VREF.n11 VSS 0.00843f
C118 VREF.t7 VSS 0.00202f
C119 VREF.t1 VSS 0.00202f
C120 VREF.n12 VSS 0.00428f
C121 VREF.n13 VSS 0.01215f
C122 VREF.n14 VSS 0.05103f
C123 VREF.n15 VSS 0.00876f
C124 VREF.t10 VSS 0.11076f
C125 VREF.n16 VSS 0.00124f
C126 VREF.n17 VSS 0.05158f
C127 VREF.n18 VSS 0.00876f
C128 VREF.n19 VSS 0.05158f
C129 VREF.t11 VSS 0.00711f
C130 VREF.n20 VSS 0.01637f
C131 VREF.n21 VSS 0.00856f
C132 VREF.n22 VSS 0.00856f
C133 VREF.t5 VSS 0.00711f
C134 VREF.n23 VSS 0.01637f
C135 VREF.t4 VSS 0.11076f
C136 VREF.n24 VSS 0.00124f
C137 VREF.n25 VSS 0.0912f
C138 VREF.t3 VSS 0.00202f
C139 VREF.t13 VSS 0.00202f
C140 VREF.n26 VSS 0.00428f
C141 VREF.n27 VSS 0.01215f
C142 VREF.n28 VSS 0.00954f
C143 VREF.t22 VSS 0.11076f
C144 VREF.n29 VSS 0.08256f
C145 VREF.t21 VSS 0.11076f
C146 VREF.n30 VSS 0.10493f
C147 VREF.t25 VSS 0.11076f
C148 VREF.n31 VSS 0.10493f
C149 VREF.t26 VSS 0.11076f
C150 VREF.n32 VSS 0.10446f
C151 VREF.n33 VSS 0.08924f
C152 VREF.t27 VSS 0.11076f
C153 VREF.n34 VSS 0.06548f
C154 VREF.t28 VSS 0.11076f
C155 VREF.n35 VSS 0.10493f
C156 VREF.t23 VSS 0.11076f
C157 VREF.n36 VSS 0.10493f
C158 VREF.t24 VSS 0.11076f
C159 VREF.n37 VSS 0.08256f
C160 VREF.n38 VSS 0.04785f
C161 VREF.n39 VSS 0.03899f
C162 VREF.t2 VSS 0.11076f
C163 VREF.n40 VSS 0
C164 VREF.n41 VSS 0.05127f
C165 VREF.n42 VSS 0.05127f
C166 VREF.t6 VSS 0.11076f
C167 VREF.n43 VSS 0.00124f
C168 VREF.n44 VSS 0.04643f
C169 VREF.n45 VSS 0.00954f
C170 VREF.t0 VSS 0.11076f
C171 VREF.n46 VSS 0.00124f
C172 VREF.n47 VSS 0.04658f
C173 VREF.t15 VSS 0.00711f
C174 VREF.n48 VSS 0.01619f
C175 VREF.n49 VSS 0.05255f
C176 VREF.t14 VSS 0.11076f
C177 VREF.n50 VSS 0.00124f
C178 VREF.n51 VSS 0.05144f
C179 VREF.n52 VSS 0.05144f
C180 VREF.t8 VSS 0.11076f
C181 VREF.n53 VSS 0.00124f
C182 VREF.n54 VSS 0.09108f
C183 VREF.t29 VSS 0.11076f
C184 VREF.n55 VSS 0.08256f
C185 VREF.t30 VSS 0.11076f
C186 VREF.n56 VSS 0.10493f
C187 VREF.t18 VSS 0.11076f
C188 VREF.n57 VSS 0.10493f
C189 VREF.t17 VSS 0.11076f
C190 VREF.n58 VSS 0.06548f
C191 VREF.n59 VSS 0.07372f
C192 VREF.n60 VSS 0.45777f
.ends
