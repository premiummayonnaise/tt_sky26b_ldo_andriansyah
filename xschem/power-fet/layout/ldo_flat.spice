* NGSPICE file created from ldo_flat.ext - technology: sky130A

.subckt ldo_flat OUT VIN VSS VDD
X0 OUT.t1024 VIN.t2110 VIN.t2111 VIN.t1 sky130_fd_pr__pfet_01v8 ad=0.1421 pd=1.56 as=0.1421 ps=1.56 w=0.49 l=0.2
X1 OUT.t1023 VIN.t2108 VIN.t2109 VIN.t167 sky130_fd_pr__pfet_01v8 ad=0.1421 pd=1.56 as=0.1421 ps=1.56 w=0.49 l=0.2
X2 OUT.t1022 VIN.t2106 VIN.t2107 VIN.t34 sky130_fd_pr__pfet_01v8 ad=0.1421 pd=1.56 as=0.1421 ps=1.56 w=0.49 l=0.2
X3 OUT.t1021 VIN.t2104 VIN.t2105 VIN.t31 sky130_fd_pr__pfet_01v8 ad=0.1421 pd=1.56 as=0.1421 ps=1.56 w=0.49 l=0.2
X4 OUT.t1020 VIN.t2102 VIN.t2103 VIN.t4 sky130_fd_pr__pfet_01v8 ad=0.1421 pd=1.56 as=0.1421 ps=1.56 w=0.49 l=0.2
X5 VIN.t2101 VIN.t2100 OUT.t1019 VIN.t240 sky130_fd_pr__pfet_01v8 ad=0.1421 pd=1.56 as=0.1421 ps=1.56 w=0.49 l=0.2
X6 VIN.t2099 VIN.t2098 OUT.t1018 VIN.t28 sky130_fd_pr__pfet_01v8 ad=0.1421 pd=1.56 as=0.1421 ps=1.56 w=0.49 l=0.2
X7 OUT.t1017 VIN.t2096 VIN.t2097 VIN.t306 sky130_fd_pr__pfet_01v8 ad=0.1421 pd=1.56 as=0.1421 ps=1.56 w=0.49 l=0.2
X8 OUT.t1016 VIN.t2094 VIN.t2095 VIN.t1 sky130_fd_pr__pfet_01v8 ad=0.1421 pd=1.56 as=0.1421 ps=1.56 w=0.49 l=0.2
X9 VIN.t2093 VIN.t2092 OUT.t1015 VIN.t360 sky130_fd_pr__pfet_01v8 ad=0.1421 pd=1.56 as=0.1421 ps=1.56 w=0.49 l=0.2
X10 OUT.t1014 VIN.t2090 VIN.t2091 VIN.t278 sky130_fd_pr__pfet_01v8 ad=0.1421 pd=1.56 as=0.1421 ps=1.56 w=0.49 l=0.2
X11 OUT.t1013 VIN.t2088 VIN.t2089 VIN.t158 sky130_fd_pr__pfet_01v8 ad=0.1421 pd=1.56 as=0.1421 ps=1.56 w=0.49 l=0.2
X12 VIN.t2087 VIN.t2086 OUT.t1012 VIN.t190 sky130_fd_pr__pfet_01v8 ad=0.1421 pd=1.56 as=0.1421 ps=1.56 w=0.49 l=0.2
X13 a_3638_4130.t3 bias-network_0.IBIAS1.t28 a_3816_4748.t7 VIN.t2142 sky130_fd_pr__pfet_01v8 ad=2.03 pd=14.58 as=1.015 ps=7.29 w=7 l=0.6
X14 OUT.t1011 VIN.t2084 VIN.t2085 VIN.t34 sky130_fd_pr__pfet_01v8 ad=0.1421 pd=1.56 as=0.1421 ps=1.56 w=0.49 l=0.2
X15 OUT.t1010 VIN.t2082 VIN.t2083 VIN.t164 sky130_fd_pr__pfet_01v8 ad=0.1421 pd=1.56 as=0.1421 ps=1.56 w=0.49 l=0.2
X16 VIN.t2081 VIN.t2080 OUT.t1009 VIN.t127 sky130_fd_pr__pfet_01v8 ad=0.1421 pd=1.56 as=0.1421 ps=1.56 w=0.49 l=0.2
X17 VIN.t2079 VIN.t2078 OUT.t1008 VIN.t25 sky130_fd_pr__pfet_01v8 ad=0.1421 pd=1.56 as=0.1421 ps=1.56 w=0.49 l=0.2
X18 OUT.t1007 VIN.t2076 VIN.t2077 VIN.t167 sky130_fd_pr__pfet_01v8 ad=0.1421 pd=1.56 as=0.1421 ps=1.56 w=0.49 l=0.2
X19 bias-network_0.VREF.t15 bias-network_0.VREF.t14 VSS.t48 VSS.t46 sky130_fd_pr__nfet_01v8 ad=0.10875 pd=1.04 as=0.10875 ps=1.04 w=0.75 l=2
X20 VIN.t2075 VIN.t2074 OUT.t1006 VIN.t130 sky130_fd_pr__pfet_01v8 ad=0.1421 pd=1.56 as=0.1421 ps=1.56 w=0.49 l=0.2
X21 OUT.t1005 VIN.t2072 VIN.t2073 VIN.t306 sky130_fd_pr__pfet_01v8 ad=0.1421 pd=1.56 as=0.1421 ps=1.56 w=0.49 l=0.2
X22 VIN.t2071 VIN.t2070 OUT.t1004 VIN.t63 sky130_fd_pr__pfet_01v8 ad=0.1421 pd=1.56 as=0.1421 ps=1.56 w=0.49 l=0.2
X23 OUT.t1003 VIN.t2068 VIN.t2069 VIN.t72 sky130_fd_pr__pfet_01v8 ad=0.1421 pd=1.56 as=0.1421 ps=1.56 w=0.49 l=0.2
X24 OUT.t1002 VIN.t2066 VIN.t2067 VIN.t31 sky130_fd_pr__pfet_01v8 ad=0.1421 pd=1.56 as=0.1421 ps=1.56 w=0.49 l=0.2
X25 VIN.t2065 VIN.t2064 OUT.t1001 VIN.t178 sky130_fd_pr__pfet_01v8 ad=0.1421 pd=1.56 as=0.1421 ps=1.56 w=0.49 l=0.2
X26 OUT.t1000 VIN.t2062 VIN.t2063 VIN.t339 sky130_fd_pr__pfet_01v8 ad=0.1421 pd=1.56 as=0.1421 ps=1.56 w=0.49 l=0.2
X27 OUT.t999 VIN.t2060 VIN.t2061 VIN.t426 sky130_fd_pr__pfet_01v8 ad=0.1421 pd=1.56 as=0.1421 ps=1.56 w=0.49 l=0.2
X28 bias-network_0.VREF.t13 bias-network_0.VREF.t12 VSS.t47 VSS.t46 sky130_fd_pr__nfet_01v8 ad=0.10875 pd=1.04 as=0.10875 ps=1.04 w=0.75 l=2
X29 OUT.t1025 VIN.t2152 sky130_fd_pr__cap_mim_m3_1 l=6 w=6
X30 VSS.t15 a_3638_4130.t12 VIN.t2128 VSS.t14 sky130_fd_pr__nfet_01v8 ad=0.15225 pd=1.34 as=0.15225 ps=1.34 w=1.05 l=0.6
X31 OUT.t998 VIN.t2058 VIN.t2059 VIN.t269 sky130_fd_pr__pfet_01v8 ad=0.1421 pd=1.56 as=0.1421 ps=1.56 w=0.49 l=0.2
X32 VIN.t2057 VIN.t2056 OUT.t997 VIN.t161 sky130_fd_pr__pfet_01v8 ad=0.1421 pd=1.56 as=0.1421 ps=1.56 w=0.49 l=0.2
X33 OUT.t996 VIN.t2054 VIN.t2055 VIN.t164 sky130_fd_pr__pfet_01v8 ad=0.1421 pd=1.56 as=0.1421 ps=1.56 w=0.49 l=0.2
X34 OUT.t995 VIN.t2052 VIN.t2053 VIN.t158 sky130_fd_pr__pfet_01v8 ad=0.1421 pd=1.56 as=0.1421 ps=1.56 w=0.49 l=0.2
X35 VIN.t2051 VIN.t2050 OUT.t994 VIN.t130 sky130_fd_pr__pfet_01v8 ad=0.1421 pd=1.56 as=0.1421 ps=1.56 w=0.49 l=0.2
X36 OUT.t993 VIN.t2048 VIN.t2049 VIN.t34 sky130_fd_pr__pfet_01v8 ad=0.1421 pd=1.56 as=0.1421 ps=1.56 w=0.49 l=0.2
X37 VIN.t2047 VIN.t2046 OUT.t992 VIN.t92 sky130_fd_pr__pfet_01v8 ad=0.1421 pd=1.56 as=0.1421 ps=1.56 w=0.49 l=0.2
X38 OUT.t991 VIN.t2044 VIN.t2045 VIN.t72 sky130_fd_pr__pfet_01v8 ad=0.1421 pd=1.56 as=0.1421 ps=1.56 w=0.49 l=0.2
X39 VIN.t2043 VIN.t2042 OUT.t990 VIN.t135 sky130_fd_pr__pfet_01v8 ad=0.1421 pd=1.56 as=0.1421 ps=1.56 w=0.49 l=0.2
X40 VIN.t2041 VIN.t2040 OUT.t989 VIN.t144 sky130_fd_pr__pfet_01v8 ad=0.1421 pd=1.56 as=0.1421 ps=1.56 w=0.49 l=0.2
X41 VIN.t2039 VIN.t2038 OUT.t988 VIN.t101 sky130_fd_pr__pfet_01v8 ad=0.1421 pd=1.56 as=0.1421 ps=1.56 w=0.49 l=0.2
X42 VIN.t2037 VIN.t2036 OUT.t987 VIN.t135 sky130_fd_pr__pfet_01v8 ad=0.1421 pd=1.56 as=0.1421 ps=1.56 w=0.49 l=0.2
X43 OUT.t986 VIN.t2034 VIN.t2035 VIN.t58 sky130_fd_pr__pfet_01v8 ad=0.1421 pd=1.56 as=0.1421 ps=1.56 w=0.49 l=0.2
X44 VIN.t2033 VIN.t2032 OUT.t985 VIN.t55 sky130_fd_pr__pfet_01v8 ad=0.1421 pd=1.56 as=0.1421 ps=1.56 w=0.49 l=0.2
X45 OUT.t984 VIN.t2030 VIN.t2031 VIN.t138 sky130_fd_pr__pfet_01v8 ad=0.1421 pd=1.56 as=0.1421 ps=1.56 w=0.49 l=0.2
X46 bias-network_0.IBIAS1.t16 bias-network_0.VREF.t17 a_816_4748.t3 VIN.t2124 sky130_fd_pr__pfet_01v8 ad=1.015 pd=7.29 as=1.015 ps=7.29 w=7 l=0.6
X47 VIN.t2029 VIN.t2028 OUT.t983 VIN.t116 sky130_fd_pr__pfet_01v8 ad=0.1421 pd=1.56 as=0.1421 ps=1.56 w=0.49 l=0.2
X48 VIN.t2027 VIN.t2026 OUT.t982 VIN.t240 sky130_fd_pr__pfet_01v8 ad=0.1421 pd=1.56 as=0.1421 ps=1.56 w=0.49 l=0.2
X49 OUT.t981 VIN.t2024 VIN.t2025 VIN.t119 sky130_fd_pr__pfet_01v8 ad=0.1421 pd=1.56 as=0.1421 ps=1.56 w=0.49 l=0.2
X50 VIN.t2023 VIN.t2022 OUT.t980 VIN.t40 sky130_fd_pr__pfet_01v8 ad=0.1421 pd=1.56 as=0.1421 ps=1.56 w=0.49 l=0.2
X51 VIN.t2021 VIN.t2020 OUT.t979 VIN.t228 sky130_fd_pr__pfet_01v8 ad=0.1421 pd=1.56 as=0.1421 ps=1.56 w=0.49 l=0.2
X52 a_3100_2480# a_2700_700# VSS.t16 sky130_fd_pr__res_xhigh_po_0p69 l=6.9
X53 VIN.t2019 VIN.t2018 OUT.t978 VIN.t161 sky130_fd_pr__pfet_01v8 ad=0.1421 pd=1.56 as=0.1421 ps=1.56 w=0.49 l=0.2
X54 bias-network_0.IBIAS1.t7 bias-network_0.IBIAS1.t6 VIN.t2147 VIN.t2146 sky130_fd_pr__pfet_01v8 ad=0.23925 pd=1.94 as=0.23925 ps=1.94 w=1.65 l=0.6
X55 VIN.t2017 VIN.t2016 OUT.t977 VIN.t111 sky130_fd_pr__pfet_01v8 ad=0.1421 pd=1.56 as=0.1421 ps=1.56 w=0.49 l=0.2
X56 OUT.t976 VIN.t2014 VIN.t2015 VIN.t108 sky130_fd_pr__pfet_01v8 ad=0.1421 pd=1.56 as=0.1421 ps=1.56 w=0.49 l=0.2
X57 OUT.t975 VIN.t2012 VIN.t2013 VIN.t43 sky130_fd_pr__pfet_01v8 ad=0.1421 pd=1.56 as=0.1421 ps=1.56 w=0.49 l=0.2
X58 VIN.t2011 VIN.t2010 OUT.t974 VIN.t211 sky130_fd_pr__pfet_01v8 ad=0.1421 pd=1.56 as=0.1421 ps=1.56 w=0.49 l=0.2
X59 VIN.t2009 VIN.t2008 OUT.t973 VIN.t37 sky130_fd_pr__pfet_01v8 ad=0.1421 pd=1.56 as=0.1421 ps=1.56 w=0.49 l=0.2
X60 VIN.t2007 VIN.t2006 OUT.t972 VIN.t360 sky130_fd_pr__pfet_01v8 ad=0.1421 pd=1.56 as=0.1421 ps=1.56 w=0.49 l=0.2
X61 OUT.t971 VIN.t2004 VIN.t2005 VIN.t19 sky130_fd_pr__pfet_01v8 ad=0.1421 pd=1.56 as=0.1421 ps=1.56 w=0.49 l=0.2
X62 VIN.t2003 VIN.t2002 OUT.t970 VIN.t95 sky130_fd_pr__pfet_01v8 ad=0.1421 pd=1.56 as=0.1421 ps=1.56 w=0.49 l=0.2
X63 OUT.t969 VIN.t2000 VIN.t2001 VIN.t72 sky130_fd_pr__pfet_01v8 ad=0.1421 pd=1.56 as=0.1421 ps=1.56 w=0.49 l=0.2
X64 VIN.t1999 VIN.t1998 OUT.t968 VIN.t211 sky130_fd_pr__pfet_01v8 ad=0.1421 pd=1.56 as=0.1421 ps=1.56 w=0.49 l=0.2
X65 OUT.t967 VIN.t1996 VIN.t1997 VIN.t87 sky130_fd_pr__pfet_01v8 ad=0.1421 pd=1.56 as=0.1421 ps=1.56 w=0.49 l=0.2
X66 OUT.t966 VIN.t1994 VIN.t1995 VIN.t69 sky130_fd_pr__pfet_01v8 ad=0.1421 pd=1.56 as=0.1421 ps=1.56 w=0.49 l=0.2
X67 OUT.t965 VIN.t1992 VIN.t1993 VIN.t16 sky130_fd_pr__pfet_01v8 ad=0.1421 pd=1.56 as=0.1421 ps=1.56 w=0.49 l=0.2
X68 OUT.t964 VIN.t1990 VIN.t1991 VIN.t13 sky130_fd_pr__pfet_01v8 ad=0.1421 pd=1.56 as=0.1421 ps=1.56 w=0.49 l=0.2
X69 OUT.t963 VIN.t1988 VIN.t1989 VIN.t58 sky130_fd_pr__pfet_01v8 ad=0.1421 pd=1.56 as=0.1421 ps=1.56 w=0.49 l=0.2
X70 OUT.t962 VIN.t1986 VIN.t1987 VIN.t4 sky130_fd_pr__pfet_01v8 ad=0.1421 pd=1.56 as=0.1421 ps=1.56 w=0.49 l=0.2
X71 OUT.t961 VIN.t1984 VIN.t1985 VIN.t69 sky130_fd_pr__pfet_01v8 ad=0.1421 pd=1.56 as=0.1421 ps=1.56 w=0.49 l=0.2
X72 OUT.t960 VIN.t1982 VIN.t1983 VIN.t185 sky130_fd_pr__pfet_01v8 ad=0.1421 pd=1.56 as=0.1421 ps=1.56 w=0.49 l=0.2
X73 VIN.t1981 VIN.t1980 OUT.t959 VIN.t55 sky130_fd_pr__pfet_01v8 ad=0.1421 pd=1.56 as=0.1421 ps=1.56 w=0.49 l=0.2
X74 OUT.t958 VIN.t1978 VIN.t1979 VIN.t324 sky130_fd_pr__pfet_01v8 ad=0.1421 pd=1.56 as=0.1421 ps=1.56 w=0.49 l=0.2
X75 OUT.t957 VIN.t1976 VIN.t1977 VIN.t87 sky130_fd_pr__pfet_01v8 ad=0.1421 pd=1.56 as=0.1421 ps=1.56 w=0.49 l=0.2
X76 VIN.t1975 VIN.t1974 OUT.t956 VIN.t46 sky130_fd_pr__pfet_01v8 ad=0.1421 pd=1.56 as=0.1421 ps=1.56 w=0.49 l=0.2
X77 VIN.t1973 VIN.t1972 OUT.t955 VIN.t82 sky130_fd_pr__pfet_01v8 ad=0.1421 pd=1.56 as=0.1421 ps=1.56 w=0.49 l=0.2
X78 VIN.t1971 VIN.t1970 OUT.t954 VIN.t49 sky130_fd_pr__pfet_01v8 ad=0.1421 pd=1.56 as=0.1421 ps=1.56 w=0.49 l=0.2
X79 VIN.t1969 VIN.t1968 OUT.t953 VIN.t28 sky130_fd_pr__pfet_01v8 ad=0.1421 pd=1.56 as=0.1421 ps=1.56 w=0.49 l=0.2
X80 OUT.t952 VIN.t1966 VIN.t1967 VIN.t4 sky130_fd_pr__pfet_01v8 ad=0.1421 pd=1.56 as=0.1421 ps=1.56 w=0.49 l=0.2
X81 a_3100_2480# divider-feedback_0.VFB.t1 VSS.t74 sky130_fd_pr__res_xhigh_po_0p69 l=6.9
X82 VIN.t1965 VIN.t1964 OUT.t951 VIN.t28 sky130_fd_pr__pfet_01v8 ad=0.1421 pd=1.56 as=0.1421 ps=1.56 w=0.49 l=0.2
X83 OUT.t950 VIN.t1962 VIN.t1963 VIN.t306 sky130_fd_pr__pfet_01v8 ad=0.1421 pd=1.56 as=0.1421 ps=1.56 w=0.49 l=0.2
X84 OUT.t949 VIN.t1960 VIN.t1961 VIN.t87 sky130_fd_pr__pfet_01v8 ad=0.1421 pd=1.56 as=0.1421 ps=1.56 w=0.49 l=0.2
X85 VIN.t1959 VIN.t1958 OUT.t948 VIN.t75 sky130_fd_pr__pfet_01v8 ad=0.1421 pd=1.56 as=0.1421 ps=1.56 w=0.49 l=0.2
X86 OUT.t947 VIN.t1956 VIN.t1957 VIN.t19 sky130_fd_pr__pfet_01v8 ad=0.1421 pd=1.56 as=0.1421 ps=1.56 w=0.49 l=0.2
X87 OUT.t946 VIN.t1954 VIN.t1955 VIN.t426 sky130_fd_pr__pfet_01v8 ad=0.1421 pd=1.56 as=0.1421 ps=1.56 w=0.49 l=0.2
X88 VIN.t1953 VIN.t1952 OUT.t945 VIN.t10 sky130_fd_pr__pfet_01v8 ad=0.1421 pd=1.56 as=0.1421 ps=1.56 w=0.49 l=0.2
X89 OUT.t944 VIN.t1950 VIN.t1951 VIN.t138 sky130_fd_pr__pfet_01v8 ad=0.1421 pd=1.56 as=0.1421 ps=1.56 w=0.49 l=0.2
X90 OUT.t943 VIN.t1948 VIN.t1949 VIN.t7 sky130_fd_pr__pfet_01v8 ad=0.1421 pd=1.56 as=0.1421 ps=1.56 w=0.49 l=0.2
X91 VIN.t1947 VIN.t1946 OUT.t942 VIN.t63 sky130_fd_pr__pfet_01v8 ad=0.1421 pd=1.56 as=0.1421 ps=1.56 w=0.49 l=0.2
X92 OUT.t941 VIN.t1944 VIN.t1945 VIN.t22 sky130_fd_pr__pfet_01v8 ad=0.1421 pd=1.56 as=0.1421 ps=1.56 w=0.49 l=0.2
X93 OUT.t940 VIN.t1942 VIN.t1943 VIN.t98 sky130_fd_pr__pfet_01v8 ad=0.1421 pd=1.56 as=0.1421 ps=1.56 w=0.49 l=0.2
X94 a_11752_2090# VDD.t0 VSS.t94 sky130_fd_pr__res_xhigh_po_0p69 l=6.9
X95 bias-network_0.VREF.t11 bias-network_0.VREF.t10 VSS.t45 VSS.t43 sky130_fd_pr__nfet_01v8 ad=0.2175 pd=2.08 as=0.10875 ps=1.04 w=0.75 l=2
X96 OUT.t939 VIN.t1940 VIN.t1941 VIN.t164 sky130_fd_pr__pfet_01v8 ad=0.1421 pd=1.56 as=0.1421 ps=1.56 w=0.49 l=0.2
X97 VIN.t1939 VIN.t1938 OUT.t938 VIN.t116 sky130_fd_pr__pfet_01v8 ad=0.1421 pd=1.56 as=0.1421 ps=1.56 w=0.49 l=0.2
X98 OUT.t937 VIN.t1936 VIN.t1937 VIN.t269 sky130_fd_pr__pfet_01v8 ad=0.1421 pd=1.56 as=0.1421 ps=1.56 w=0.49 l=0.2
X99 VIN.t1935 VIN.t1934 OUT.t936 VIN.t66 sky130_fd_pr__pfet_01v8 ad=0.1421 pd=1.56 as=0.1421 ps=1.56 w=0.49 l=0.2
X100 VIN.t1933 VIN.t1932 OUT.t935 VIN.t10 sky130_fd_pr__pfet_01v8 ad=0.1421 pd=1.56 as=0.1421 ps=1.56 w=0.49 l=0.2
X101 VIN.t1931 VIN.t1930 OUT.t934 VIN.t124 sky130_fd_pr__pfet_01v8 ad=0.1421 pd=1.56 as=0.1421 ps=1.56 w=0.49 l=0.2
X102 VIN.t1929 VIN.t1928 OUT.t933 VIN.t240 sky130_fd_pr__pfet_01v8 ad=0.1421 pd=1.56 as=0.1421 ps=1.56 w=0.49 l=0.2
X103 VIN.t1927 VIN.t1926 OUT.t932 VIN.t63 sky130_fd_pr__pfet_01v8 ad=0.1421 pd=1.56 as=0.1421 ps=1.56 w=0.49 l=0.2
X104 bias-network_0.VREF.t9 bias-network_0.VREF.t8 VSS.t44 VSS.t43 sky130_fd_pr__nfet_01v8 ad=0.2175 pd=2.08 as=0.10875 ps=1.04 w=0.75 l=2
X105 VIN.t1925 VIN.t1924 OUT.t931 VIN.t360 sky130_fd_pr__pfet_01v8 ad=0.1421 pd=1.56 as=0.1421 ps=1.56 w=0.49 l=0.2
X106 VIN.t1923 VIN.t1922 OUT.t930 VIN.t135 sky130_fd_pr__pfet_01v8 ad=0.1421 pd=1.56 as=0.1421 ps=1.56 w=0.49 l=0.2
X107 OUT.t929 VIN.t1920 VIN.t1921 VIN.t108 sky130_fd_pr__pfet_01v8 ad=0.1421 pd=1.56 as=0.1421 ps=1.56 w=0.49 l=0.2
X108 VIN.t1919 VIN.t1918 OUT.t928 VIN.t144 sky130_fd_pr__pfet_01v8 ad=0.1421 pd=1.56 as=0.1421 ps=1.56 w=0.49 l=0.2
X109 VIN.t1917 VIN.t1916 OUT.t927 VIN.t127 sky130_fd_pr__pfet_01v8 ad=0.1421 pd=1.56 as=0.1421 ps=1.56 w=0.49 l=0.2
X110 a_816_4748.t8 bias-network_0.IBIAS2.t16 VIN.t2121 VIN.t2120 sky130_fd_pr__pfet_01v8 ad=0.23925 pd=1.94 as=0.23925 ps=1.94 w=1.65 l=0.6
X111 VSS.t96 VSS.t97 VSS.t95 sky130_fd_pr__res_xhigh_po_0p69 l=6.9
X112 VIN.t1915 VIN.t1914 OUT.t926 VIN.t116 sky130_fd_pr__pfet_01v8 ad=0.1421 pd=1.56 as=0.1421 ps=1.56 w=0.49 l=0.2
X113 OUT.t925 VIN.t1912 VIN.t1913 VIN.t155 sky130_fd_pr__pfet_01v8 ad=0.1421 pd=1.56 as=0.1421 ps=1.56 w=0.49 l=0.2
X114 OUT.t924 VIN.t1910 VIN.t1911 VIN.t306 sky130_fd_pr__pfet_01v8 ad=0.1421 pd=1.56 as=0.1421 ps=1.56 w=0.49 l=0.2
X115 OUT.t923 VIN.t1908 VIN.t1909 VIN.t278 sky130_fd_pr__pfet_01v8 ad=0.1421 pd=1.56 as=0.1421 ps=1.56 w=0.49 l=0.2
X116 VIN.t1907 VIN.t1906 OUT.t922 VIN.t240 sky130_fd_pr__pfet_01v8 ad=0.1421 pd=1.56 as=0.1421 ps=1.56 w=0.49 l=0.2
X117 OUT.t921 VIN.t1904 VIN.t1905 VIN.t72 sky130_fd_pr__pfet_01v8 ad=0.1421 pd=1.56 as=0.1421 ps=1.56 w=0.49 l=0.2
X118 VSS.t99 VSS.t100 VSS.t98 sky130_fd_pr__res_xhigh_po_0p69 l=6.9
X119 VIN.t1903 VIN.t1902 OUT.t920 VIN.t233 sky130_fd_pr__pfet_01v8 ad=0.1421 pd=1.56 as=0.1421 ps=1.56 w=0.49 l=0.2
X120 OUT.t919 VIN.t1900 VIN.t1901 VIN.t164 sky130_fd_pr__pfet_01v8 ad=0.1421 pd=1.56 as=0.1421 ps=1.56 w=0.49 l=0.2
X121 VIN.t1899 VIN.t1898 OUT.t918 VIN.t111 sky130_fd_pr__pfet_01v8 ad=0.1421 pd=1.56 as=0.1421 ps=1.56 w=0.49 l=0.2
X122 OUT.t917 VIN.t1896 VIN.t1897 VIN.t426 sky130_fd_pr__pfet_01v8 ad=0.1421 pd=1.56 as=0.1421 ps=1.56 w=0.49 l=0.2
X123 VIN.t1895 VIN.t1894 OUT.t916 VIN.t75 sky130_fd_pr__pfet_01v8 ad=0.1421 pd=1.56 as=0.1421 ps=1.56 w=0.49 l=0.2
X124 OUT.t915 VIN.t1892 VIN.t1893 VIN.t339 sky130_fd_pr__pfet_01v8 ad=0.1421 pd=1.56 as=0.1421 ps=1.56 w=0.49 l=0.2
X125 OUT.t914 VIN.t1890 VIN.t1891 VIN.t269 sky130_fd_pr__pfet_01v8 ad=0.1421 pd=1.56 as=0.1421 ps=1.56 w=0.49 l=0.2
X126 VIN.t1889 VIN.t1888 OUT.t913 VIN.t95 sky130_fd_pr__pfet_01v8 ad=0.1421 pd=1.56 as=0.1421 ps=1.56 w=0.49 l=0.2
X127 VIN.t1887 VIN.t1886 OUT.t912 VIN.t144 sky130_fd_pr__pfet_01v8 ad=0.1421 pd=1.56 as=0.1421 ps=1.56 w=0.49 l=0.2
X128 VIN.t1885 VIN.t1884 OUT.t911 VIN.t233 sky130_fd_pr__pfet_01v8 ad=0.1421 pd=1.56 as=0.1421 ps=1.56 w=0.49 l=0.2
X129 VIN.t1883 VIN.t1882 OUT.t910 VIN.t211 sky130_fd_pr__pfet_01v8 ad=0.1421 pd=1.56 as=0.1421 ps=1.56 w=0.49 l=0.2
X130 OUT.t909 VIN.t1880 VIN.t1881 VIN.t16 sky130_fd_pr__pfet_01v8 ad=0.1421 pd=1.56 as=0.1421 ps=1.56 w=0.49 l=0.2
X131 OUT.t908 VIN.t1878 VIN.t1879 VIN.t58 sky130_fd_pr__pfet_01v8 ad=0.1421 pd=1.56 as=0.1421 ps=1.56 w=0.49 l=0.2
X132 VIN.t1877 VIN.t1876 OUT.t907 VIN.t124 sky130_fd_pr__pfet_01v8 ad=0.1421 pd=1.56 as=0.1421 ps=1.56 w=0.49 l=0.2
X133 VIN.t1875 VIN.t1874 OUT.t906 VIN.t92 sky130_fd_pr__pfet_01v8 ad=0.1421 pd=1.56 as=0.1421 ps=1.56 w=0.49 l=0.2
X134 OUT.t905 VIN.t1872 VIN.t1873 VIN.t72 sky130_fd_pr__pfet_01v8 ad=0.1421 pd=1.56 as=0.1421 ps=1.56 w=0.49 l=0.2
X135 VIN.t1871 VIN.t1870 OUT.t904 VIN.t116 sky130_fd_pr__pfet_01v8 ad=0.1421 pd=1.56 as=0.1421 ps=1.56 w=0.49 l=0.2
X136 VIN.t1869 VIN.t1868 OUT.t903 VIN.t111 sky130_fd_pr__pfet_01v8 ad=0.1421 pd=1.56 as=0.1421 ps=1.56 w=0.49 l=0.2
X137 a_10152_2090# a_10352_310# VSS.t75 sky130_fd_pr__res_xhigh_po_0p69 l=6.9
X138 VIN.t1867 VIN.t1866 OUT.t902 VIN.t395 sky130_fd_pr__pfet_01v8 ad=0.1421 pd=1.56 as=0.1421 ps=1.56 w=0.49 l=0.2
X139 VIN.t1865 VIN.t1864 OUT.t901 VIN.t111 sky130_fd_pr__pfet_01v8 ad=0.1421 pd=1.56 as=0.1421 ps=1.56 w=0.49 l=0.2
X140 OUT.t900 VIN.t1862 VIN.t1863 VIN.t426 sky130_fd_pr__pfet_01v8 ad=0.1421 pd=1.56 as=0.1421 ps=1.56 w=0.49 l=0.2
X141 OUT.t899 VIN.t1860 VIN.t1861 VIN.t339 sky130_fd_pr__pfet_01v8 ad=0.1421 pd=1.56 as=0.1421 ps=1.56 w=0.49 l=0.2
X142 OUT.t898 VIN.t1858 VIN.t1859 VIN.t185 sky130_fd_pr__pfet_01v8 ad=0.1421 pd=1.56 as=0.1421 ps=1.56 w=0.49 l=0.2
X143 VIN.t1857 VIN.t1856 OUT.t897 VIN.t40 sky130_fd_pr__pfet_01v8 ad=0.1421 pd=1.56 as=0.1421 ps=1.56 w=0.49 l=0.2
X144 VIN.t1855 VIN.t1854 OUT.t896 VIN.t228 sky130_fd_pr__pfet_01v8 ad=0.1421 pd=1.56 as=0.1421 ps=1.56 w=0.49 l=0.2
X145 OUT.t895 VIN.t1852 VIN.t1853 VIN.t119 sky130_fd_pr__pfet_01v8 ad=0.1421 pd=1.56 as=0.1421 ps=1.56 w=0.49 l=0.2
X146 OUT.t894 VIN.t1850 VIN.t1851 VIN.t16 sky130_fd_pr__pfet_01v8 ad=0.1421 pd=1.56 as=0.1421 ps=1.56 w=0.49 l=0.2
X147 OUT.t893 VIN.t1848 VIN.t1849 VIN.t43 sky130_fd_pr__pfet_01v8 ad=0.1421 pd=1.56 as=0.1421 ps=1.56 w=0.49 l=0.2
X148 OUT.t892 VIN.t1846 VIN.t1847 VIN.t19 sky130_fd_pr__pfet_01v8 ad=0.1421 pd=1.56 as=0.1421 ps=1.56 w=0.49 l=0.2
X149 VIN.t1845 VIN.t1844 OUT.t891 VIN.t211 sky130_fd_pr__pfet_01v8 ad=0.1421 pd=1.56 as=0.1421 ps=1.56 w=0.49 l=0.2
X150 VIN.t1843 VIN.t1842 OUT.t890 VIN.t28 sky130_fd_pr__pfet_01v8 ad=0.1421 pd=1.56 as=0.1421 ps=1.56 w=0.49 l=0.2
X151 OUT.t889 VIN.t1840 VIN.t1841 VIN.t1 sky130_fd_pr__pfet_01v8 ad=0.1421 pd=1.56 as=0.1421 ps=1.56 w=0.49 l=0.2
X152 VIN.t1839 VIN.t1838 OUT.t888 VIN.t37 sky130_fd_pr__pfet_01v8 ad=0.1421 pd=1.56 as=0.1421 ps=1.56 w=0.49 l=0.2
X153 VIN.t1837 VIN.t1836 OUT.t887 VIN.t360 sky130_fd_pr__pfet_01v8 ad=0.1421 pd=1.56 as=0.1421 ps=1.56 w=0.49 l=0.2
X154 OUT.t886 VIN.t1834 VIN.t1835 VIN.t324 sky130_fd_pr__pfet_01v8 ad=0.1421 pd=1.56 as=0.1421 ps=1.56 w=0.49 l=0.2
X155 VIN.t1833 VIN.t1832 OUT.t885 VIN.t161 sky130_fd_pr__pfet_01v8 ad=0.1421 pd=1.56 as=0.1421 ps=1.56 w=0.49 l=0.2
X156 a_1700_2480# a_2100_700# VSS.t49 sky130_fd_pr__res_xhigh_po_0p69 l=6.9
X157 OUT.t884 VIN.t1830 VIN.t1831 VIN.t7 sky130_fd_pr__pfet_01v8 ad=0.1421 pd=1.56 as=0.1421 ps=1.56 w=0.49 l=0.2
X158 VIN.t1829 VIN.t1828 OUT.t883 VIN.t95 sky130_fd_pr__pfet_01v8 ad=0.1421 pd=1.56 as=0.1421 ps=1.56 w=0.49 l=0.2
X159 OUT.t882 VIN.t1826 VIN.t1827 VIN.t167 sky130_fd_pr__pfet_01v8 ad=0.1421 pd=1.56 as=0.1421 ps=1.56 w=0.49 l=0.2
X160 VIN.t1825 VIN.t1824 OUT.t881 VIN.t228 sky130_fd_pr__pfet_01v8 ad=0.1421 pd=1.56 as=0.1421 ps=1.56 w=0.49 l=0.2
X161 VIN.t1823 VIN.t1822 OUT.t880 VIN.t40 sky130_fd_pr__pfet_01v8 ad=0.1421 pd=1.56 as=0.1421 ps=1.56 w=0.49 l=0.2
X162 OUT.t879 VIN.t1820 VIN.t1821 VIN.t52 sky130_fd_pr__pfet_01v8 ad=0.1421 pd=1.56 as=0.1421 ps=1.56 w=0.49 l=0.2
X163 VIN.t1819 VIN.t1818 OUT.t878 VIN.t28 sky130_fd_pr__pfet_01v8 ad=0.1421 pd=1.56 as=0.1421 ps=1.56 w=0.49 l=0.2
X164 VIN.t1817 VIN.t1816 OUT.t877 VIN.t360 sky130_fd_pr__pfet_01v8 ad=0.1421 pd=1.56 as=0.1421 ps=1.56 w=0.49 l=0.2
X165 OUT.t876 VIN.t1814 VIN.t1815 VIN.t158 sky130_fd_pr__pfet_01v8 ad=0.1421 pd=1.56 as=0.1421 ps=1.56 w=0.49 l=0.2
X166 OUT.t875 VIN.t1812 VIN.t1813 VIN.t164 sky130_fd_pr__pfet_01v8 ad=0.1421 pd=1.56 as=0.1421 ps=1.56 w=0.49 l=0.2
X167 VIN.t1811 VIN.t1810 OUT.t874 VIN.t116 sky130_fd_pr__pfet_01v8 ad=0.1421 pd=1.56 as=0.1421 ps=1.56 w=0.49 l=0.2
X168 OUT.t873 VIN.t1808 VIN.t1809 VIN.t324 sky130_fd_pr__pfet_01v8 ad=0.1421 pd=1.56 as=0.1421 ps=1.56 w=0.49 l=0.2
X169 VIN.t1807 VIN.t1806 OUT.t872 VIN.t124 sky130_fd_pr__pfet_01v8 ad=0.1421 pd=1.56 as=0.1421 ps=1.56 w=0.49 l=0.2
X170 VIN.t1805 VIN.t1804 OUT.t871 VIN.t55 sky130_fd_pr__pfet_01v8 ad=0.1421 pd=1.56 as=0.1421 ps=1.56 w=0.49 l=0.2
X171 OUT.t870 VIN.t1802 VIN.t1803 VIN.t7 sky130_fd_pr__pfet_01v8 ad=0.1421 pd=1.56 as=0.1421 ps=1.56 w=0.49 l=0.2
X172 VIN.t1801 VIN.t1800 OUT.t869 VIN.t313 sky130_fd_pr__pfet_01v8 ad=0.1421 pd=1.56 as=0.1421 ps=1.56 w=0.49 l=0.2
X173 VIN.t1799 VIN.t1798 OUT.t868 VIN.t28 sky130_fd_pr__pfet_01v8 ad=0.1421 pd=1.56 as=0.1421 ps=1.56 w=0.49 l=0.2
X174 OUT.t867 VIN.t1796 VIN.t1797 VIN.t87 sky130_fd_pr__pfet_01v8 ad=0.1421 pd=1.56 as=0.1421 ps=1.56 w=0.49 l=0.2
X175 VIN.t1795 VIN.t1794 OUT.t866 VIN.t360 sky130_fd_pr__pfet_01v8 ad=0.1421 pd=1.56 as=0.1421 ps=1.56 w=0.49 l=0.2
X176 OUT.t865 VIN.t1792 VIN.t1793 VIN.t141 sky130_fd_pr__pfet_01v8 ad=0.1421 pd=1.56 as=0.1421 ps=1.56 w=0.49 l=0.2
X177 VIN.t1791 VIN.t1790 OUT.t864 VIN.t178 sky130_fd_pr__pfet_01v8 ad=0.1421 pd=1.56 as=0.1421 ps=1.56 w=0.49 l=0.2
X178 OUT.t863 VIN.t1788 VIN.t1789 VIN.t306 sky130_fd_pr__pfet_01v8 ad=0.1421 pd=1.56 as=0.1421 ps=1.56 w=0.49 l=0.2
X179 VIN.t1787 VIN.t1786 OUT.t862 VIN.t178 sky130_fd_pr__pfet_01v8 ad=0.1421 pd=1.56 as=0.1421 ps=1.56 w=0.49 l=0.2
X180 OUT.t861 VIN.t1784 VIN.t1785 VIN.t301 sky130_fd_pr__pfet_01v8 ad=0.1421 pd=1.56 as=0.1421 ps=1.56 w=0.49 l=0.2
X181 OUT.t860 VIN.t1782 VIN.t1783 VIN.t426 sky130_fd_pr__pfet_01v8 ad=0.1421 pd=1.56 as=0.1421 ps=1.56 w=0.49 l=0.2
X182 VIN.t1781 VIN.t1780 OUT.t859 VIN.t130 sky130_fd_pr__pfet_01v8 ad=0.1421 pd=1.56 as=0.1421 ps=1.56 w=0.49 l=0.2
X183 OUT.t858 VIN.t1778 VIN.t1779 VIN.t306 sky130_fd_pr__pfet_01v8 ad=0.1421 pd=1.56 as=0.1421 ps=1.56 w=0.49 l=0.2
X184 OUT.t857 VIN.t1776 VIN.t1777 VIN.t19 sky130_fd_pr__pfet_01v8 ad=0.1421 pd=1.56 as=0.1421 ps=1.56 w=0.49 l=0.2
X185 VIN.t1775 VIN.t1774 OUT.t856 VIN.t92 sky130_fd_pr__pfet_01v8 ad=0.1421 pd=1.56 as=0.1421 ps=1.56 w=0.49 l=0.2
X186 OUT.t855 VIN.t1772 VIN.t1773 VIN.t98 sky130_fd_pr__pfet_01v8 ad=0.1421 pd=1.56 as=0.1421 ps=1.56 w=0.49 l=0.2
X187 a_2500_2480# a_2100_700# VSS.t50 sky130_fd_pr__res_xhigh_po_0p69 l=6.9
X188 OUT.t854 VIN.t1770 VIN.t1771 VIN.t324 sky130_fd_pr__pfet_01v8 ad=0.1421 pd=1.56 as=0.1421 ps=1.56 w=0.49 l=0.2
X189 VIN.t1769 VIN.t1768 OUT.t853 VIN.t82 sky130_fd_pr__pfet_01v8 ad=0.1421 pd=1.56 as=0.1421 ps=1.56 w=0.49 l=0.2
X190 a_3638_4130.t11 a_3638_4130.t10 VSS.t13 VSS.t12 sky130_fd_pr__nfet_01v8 ad=0.15225 pd=1.34 as=0.15225 ps=1.34 w=1.05 l=0.6
X191 a_816_4748.t7 error-amplifier_0.VN a_638_4130.t3 VIN.t2115 sky130_fd_pr__pfet_01v8 ad=1.015 pd=7.29 as=1.015 ps=7.29 w=7 l=0.6
X192 VIN.t1767 VIN.t1766 OUT.t852 VIN.t75 sky130_fd_pr__pfet_01v8 ad=0.1421 pd=1.56 as=0.1421 ps=1.56 w=0.49 l=0.2
X193 VIN.t1765 VIN.t1764 OUT.t851 VIN.t360 sky130_fd_pr__pfet_01v8 ad=0.1421 pd=1.56 as=0.1421 ps=1.56 w=0.49 l=0.2
X194 OUT.t850 VIN.t1762 VIN.t1763 VIN.t269 sky130_fd_pr__pfet_01v8 ad=0.1421 pd=1.56 as=0.1421 ps=1.56 w=0.49 l=0.2
X195 VIN.t1761 VIN.t1760 OUT.t849 VIN.t55 sky130_fd_pr__pfet_01v8 ad=0.1421 pd=1.56 as=0.1421 ps=1.56 w=0.49 l=0.2
X196 OUT.t848 VIN.t1758 VIN.t1759 VIN.t301 sky130_fd_pr__pfet_01v8 ad=0.1421 pd=1.56 as=0.1421 ps=1.56 w=0.49 l=0.2
X197 VIN.t1757 VIN.t1756 OUT.t847 VIN.t101 sky130_fd_pr__pfet_01v8 ad=0.1421 pd=1.56 as=0.1421 ps=1.56 w=0.49 l=0.2
X198 OUT.t846 VIN.t1754 VIN.t1755 VIN.t306 sky130_fd_pr__pfet_01v8 ad=0.1421 pd=1.56 as=0.1421 ps=1.56 w=0.49 l=0.2
X199 VIN.t1753 VIN.t1752 OUT.t845 VIN.t92 sky130_fd_pr__pfet_01v8 ad=0.1421 pd=1.56 as=0.1421 ps=1.56 w=0.49 l=0.2
X200 OUT.t844 VIN.t1750 VIN.t1751 VIN.t58 sky130_fd_pr__pfet_01v8 ad=0.1421 pd=1.56 as=0.1421 ps=1.56 w=0.49 l=0.2
X201 OUT.t843 VIN.t1748 VIN.t1749 VIN.t7 sky130_fd_pr__pfet_01v8 ad=0.1421 pd=1.56 as=0.1421 ps=1.56 w=0.49 l=0.2
X202 OUT.t842 VIN.t1746 VIN.t1747 VIN.t108 sky130_fd_pr__pfet_01v8 ad=0.1421 pd=1.56 as=0.1421 ps=1.56 w=0.49 l=0.2
X203 a_816_4748.t2 bias-network_0.VREF.t18 bias-network_0.IBIAS1.t17 VIN.t2126 sky130_fd_pr__pfet_01v8 ad=1.015 pd=7.29 as=1.015 ps=7.29 w=7 l=0.6
X204 OUT.t841 VIN.t1744 VIN.t1745 VIN.t185 sky130_fd_pr__pfet_01v8 ad=0.1421 pd=1.56 as=0.1421 ps=1.56 w=0.49 l=0.2
X205 OUT.t840 VIN.t1742 VIN.t1743 VIN.t98 sky130_fd_pr__pfet_01v8 ad=0.1421 pd=1.56 as=0.1421 ps=1.56 w=0.49 l=0.2
X206 OUT.t839 VIN.t1740 VIN.t1741 VIN.t108 sky130_fd_pr__pfet_01v8 ad=0.1421 pd=1.56 as=0.1421 ps=1.56 w=0.49 l=0.2
X207 VIN.t1739 VIN.t1738 OUT.t838 VIN.t135 sky130_fd_pr__pfet_01v8 ad=0.1421 pd=1.56 as=0.1421 ps=1.56 w=0.49 l=0.2
X208 VSS.t42 bias-network_0.VREF.t19 bias-network_0.IBIAS1.t18 VSS.t29 sky130_fd_pr__nfet_01v8 ad=0.10875 pd=1.04 as=0.10875 ps=1.04 w=0.75 l=2
X209 VIN.t1737 VIN.t1736 OUT.t837 VIN.t144 sky130_fd_pr__pfet_01v8 ad=0.1421 pd=1.56 as=0.1421 ps=1.56 w=0.49 l=0.2
X210 VIN.t2123 bias-network_0.IBIAS2.t17 a_816_4748.t9 VIN.t2122 sky130_fd_pr__pfet_01v8 ad=0.23925 pd=1.94 as=0.23925 ps=1.94 w=1.65 l=0.6
X211 VIN.t1735 VIN.t1734 OUT.t836 VIN.t240 sky130_fd_pr__pfet_01v8 ad=0.1421 pd=1.56 as=0.1421 ps=1.56 w=0.49 l=0.2
X212 VIN.t1733 VIN.t1732 OUT.t835 VIN.t127 sky130_fd_pr__pfet_01v8 ad=0.1421 pd=1.56 as=0.1421 ps=1.56 w=0.49 l=0.2
X213 OUT.t834 VIN.t1730 VIN.t1731 VIN.t13 sky130_fd_pr__pfet_01v8 ad=0.1421 pd=1.56 as=0.1421 ps=1.56 w=0.49 l=0.2
X214 VSS.t41 bias-network_0.VREF.t20 bias-network_0.IBIAS1.t19 VSS.t29 sky130_fd_pr__nfet_01v8 ad=0.10875 pd=1.04 as=0.10875 ps=1.04 w=0.75 l=2
X215 VIN.t1729 VIN.t1728 OUT.t833 VIN.t233 sky130_fd_pr__pfet_01v8 ad=0.1421 pd=1.56 as=0.1421 ps=1.56 w=0.49 l=0.2
X216 OUT.t832 VIN.t1726 VIN.t1727 VIN.t16 sky130_fd_pr__pfet_01v8 ad=0.1421 pd=1.56 as=0.1421 ps=1.56 w=0.49 l=0.2
X217 OUT.t831 VIN.t1724 VIN.t1725 VIN.t69 sky130_fd_pr__pfet_01v8 ad=0.1421 pd=1.56 as=0.1421 ps=1.56 w=0.49 l=0.2
X218 VIN.t1723 VIN.t1722 OUT.t830 VIN.t92 sky130_fd_pr__pfet_01v8 ad=0.1421 pd=1.56 as=0.1421 ps=1.56 w=0.49 l=0.2
X219 a_2500_2480# a_2900_700# VSS.t85 sky130_fd_pr__res_xhigh_po_0p69 l=6.9
X220 VIN.t1721 VIN.t1720 OUT.t829 VIN.t395 sky130_fd_pr__pfet_01v8 ad=0.1421 pd=1.56 as=0.1421 ps=1.56 w=0.49 l=0.2
X221 OUT.t828 VIN.t1718 VIN.t1719 VIN.t269 sky130_fd_pr__pfet_01v8 ad=0.1421 pd=1.56 as=0.1421 ps=1.56 w=0.49 l=0.2
X222 VIN.t1717 VIN.t1716 OUT.t827 VIN.t95 sky130_fd_pr__pfet_01v8 ad=0.1421 pd=1.56 as=0.1421 ps=1.56 w=0.49 l=0.2
X223 OUT.t826 VIN.t1714 VIN.t1715 VIN.t1 sky130_fd_pr__pfet_01v8 ad=0.1421 pd=1.56 as=0.1421 ps=1.56 w=0.49 l=0.2
X224 VIN.t1713 VIN.t1712 OUT.t825 VIN.t228 sky130_fd_pr__pfet_01v8 ad=0.1421 pd=1.56 as=0.1421 ps=1.56 w=0.49 l=0.2
X225 VIN.t1711 VIN.t1710 OUT.t824 VIN.t233 sky130_fd_pr__pfet_01v8 ad=0.1421 pd=1.56 as=0.1421 ps=1.56 w=0.49 l=0.2
X226 VIN.t1709 VIN.t1708 OUT.t823 VIN.t211 sky130_fd_pr__pfet_01v8 ad=0.1421 pd=1.56 as=0.1421 ps=1.56 w=0.49 l=0.2
X227 OUT.t822 VIN.t1706 VIN.t1707 VIN.t69 sky130_fd_pr__pfet_01v8 ad=0.1421 pd=1.56 as=0.1421 ps=1.56 w=0.49 l=0.2
X228 a_n100_2480# a_300_700# VSS.t86 sky130_fd_pr__res_xhigh_po_0p69 l=6.9
X229 VIN.t1705 VIN.t1704 OUT.t821 VIN.t190 sky130_fd_pr__pfet_01v8 ad=0.1421 pd=1.56 as=0.1421 ps=1.56 w=0.49 l=0.2
X230 VIN.t1703 VIN.t1702 OUT.t820 VIN.t111 sky130_fd_pr__pfet_01v8 ad=0.1421 pd=1.56 as=0.1421 ps=1.56 w=0.49 l=0.2
X231 VIN.t1701 VIN.t1700 OUT.t819 VIN.t233 sky130_fd_pr__pfet_01v8 ad=0.1421 pd=1.56 as=0.1421 ps=1.56 w=0.49 l=0.2
X232 VIN.t1699 VIN.t1698 OUT.t818 VIN.t49 sky130_fd_pr__pfet_01v8 ad=0.1421 pd=1.56 as=0.1421 ps=1.56 w=0.49 l=0.2
X233 OUT.t817 VIN.t1696 VIN.t1697 VIN.t4 sky130_fd_pr__pfet_01v8 ad=0.1421 pd=1.56 as=0.1421 ps=1.56 w=0.49 l=0.2
X234 VIN.t1695 VIN.t1694 OUT.t816 VIN.t82 sky130_fd_pr__pfet_01v8 ad=0.1421 pd=1.56 as=0.1421 ps=1.56 w=0.49 l=0.2
X235 VIN.t1693 VIN.t1692 OUT.t815 VIN.t46 sky130_fd_pr__pfet_01v8 ad=0.1421 pd=1.56 as=0.1421 ps=1.56 w=0.49 l=0.2
X236 VIN.t1691 VIN.t1690 OUT.t814 VIN.t395 sky130_fd_pr__pfet_01v8 ad=0.1421 pd=1.56 as=0.1421 ps=1.56 w=0.49 l=0.2
X237 OUT.t813 VIN.t1688 VIN.t1689 VIN.t158 sky130_fd_pr__pfet_01v8 ad=0.1421 pd=1.56 as=0.1421 ps=1.56 w=0.49 l=0.2
X238 VIN.t1687 VIN.t1686 OUT.t812 VIN.t75 sky130_fd_pr__pfet_01v8 ad=0.1421 pd=1.56 as=0.1421 ps=1.56 w=0.49 l=0.2
X239 OUT.t811 VIN.t1684 VIN.t1685 VIN.t43 sky130_fd_pr__pfet_01v8 ad=0.1421 pd=1.56 as=0.1421 ps=1.56 w=0.49 l=0.2
X240 OUT.t810 VIN.t1682 VIN.t1683 VIN.t185 sky130_fd_pr__pfet_01v8 ad=0.1421 pd=1.56 as=0.1421 ps=1.56 w=0.49 l=0.2
X241 OUT.t809 VIN.t1680 VIN.t1681 VIN.t164 sky130_fd_pr__pfet_01v8 ad=0.1421 pd=1.56 as=0.1421 ps=1.56 w=0.49 l=0.2
X242 OUT.t808 VIN.t1678 VIN.t1679 VIN.t138 sky130_fd_pr__pfet_01v8 ad=0.1421 pd=1.56 as=0.1421 ps=1.56 w=0.49 l=0.2
X243 VIN.t1677 VIN.t1676 OUT.t807 VIN.t25 sky130_fd_pr__pfet_01v8 ad=0.1421 pd=1.56 as=0.1421 ps=1.56 w=0.49 l=0.2
X244 VIN.t1675 VIN.t1674 OUT.t806 VIN.t313 sky130_fd_pr__pfet_01v8 ad=0.1421 pd=1.56 as=0.1421 ps=1.56 w=0.49 l=0.2
X245 VIN.t1673 VIN.t1672 OUT.t805 VIN.t178 sky130_fd_pr__pfet_01v8 ad=0.1421 pd=1.56 as=0.1421 ps=1.56 w=0.49 l=0.2
X246 OUT.t804 VIN.t1670 VIN.t1671 VIN.t43 sky130_fd_pr__pfet_01v8 ad=0.1421 pd=1.56 as=0.1421 ps=1.56 w=0.49 l=0.2
X247 VIN.t1669 VIN.t1668 OUT.t803 VIN.t127 sky130_fd_pr__pfet_01v8 ad=0.1421 pd=1.56 as=0.1421 ps=1.56 w=0.49 l=0.2
X248 OUT.t802 VIN.t1666 VIN.t1667 VIN.t324 sky130_fd_pr__pfet_01v8 ad=0.1421 pd=1.56 as=0.1421 ps=1.56 w=0.49 l=0.2
X249 VIN.t1665 VIN.t1664 OUT.t801 VIN.t161 sky130_fd_pr__pfet_01v8 ad=0.1421 pd=1.56 as=0.1421 ps=1.56 w=0.49 l=0.2
X250 VIN.t1663 VIN.t1662 OUT.t800 VIN.t111 sky130_fd_pr__pfet_01v8 ad=0.1421 pd=1.56 as=0.1421 ps=1.56 w=0.49 l=0.2
X251 VIN.t1661 VIN.t1660 OUT.t799 VIN.t37 sky130_fd_pr__pfet_01v8 ad=0.1421 pd=1.56 as=0.1421 ps=1.56 w=0.49 l=0.2
X252 bias-network_0.IBIAS1.t12 a_638_4130.t12 VSS.t110 VSS.t109 sky130_fd_pr__nfet_01v8 ad=0.15225 pd=1.34 as=0.15225 ps=1.34 w=1.05 l=0.6
X253 OUT.t798 VIN.t1658 VIN.t1659 VIN.t426 sky130_fd_pr__pfet_01v8 ad=0.1421 pd=1.56 as=0.1421 ps=1.56 w=0.49 l=0.2
X254 OUT.t797 VIN.t1656 VIN.t1657 VIN.t167 sky130_fd_pr__pfet_01v8 ad=0.1421 pd=1.56 as=0.1421 ps=1.56 w=0.49 l=0.2
X255 OUT.t796 VIN.t1654 VIN.t1655 VIN.t155 sky130_fd_pr__pfet_01v8 ad=0.1421 pd=1.56 as=0.1421 ps=1.56 w=0.49 l=0.2
X256 OUT.t795 VIN.t1652 VIN.t1653 VIN.t52 sky130_fd_pr__pfet_01v8 ad=0.1421 pd=1.56 as=0.1421 ps=1.56 w=0.49 l=0.2
X257 VIN.t1651 VIN.t1650 OUT.t794 VIN.t66 sky130_fd_pr__pfet_01v8 ad=0.1421 pd=1.56 as=0.1421 ps=1.56 w=0.49 l=0.2
X258 a_700_2480# a_300_700# VSS.t87 sky130_fd_pr__res_xhigh_po_0p69 l=6.9
X259 a_700_2480# a_1100_700# VSS.t88 sky130_fd_pr__res_xhigh_po_0p69 l=6.9
X260 OUT.t793 VIN.t1648 VIN.t1649 VIN.t141 sky130_fd_pr__pfet_01v8 ad=0.1421 pd=1.56 as=0.1421 ps=1.56 w=0.49 l=0.2
X261 a_8152_2090# bias-network_0.VREF.t16 VSS.t89 sky130_fd_pr__res_xhigh_po_0p69 l=6.9
X262 OUT.t792 VIN.t1646 VIN.t1647 VIN.t119 sky130_fd_pr__pfet_01v8 ad=0.1421 pd=1.56 as=0.1421 ps=1.56 w=0.49 l=0.2
X263 OUT.t791 VIN.t1644 VIN.t1645 VIN.t339 sky130_fd_pr__pfet_01v8 ad=0.1421 pd=1.56 as=0.1421 ps=1.56 w=0.49 l=0.2
X264 VIN.t1643 VIN.t1642 OUT.t790 VIN.t124 sky130_fd_pr__pfet_01v8 ad=0.1421 pd=1.56 as=0.1421 ps=1.56 w=0.49 l=0.2
X265 VIN.t1641 VIN.t1640 OUT.t789 VIN.t116 sky130_fd_pr__pfet_01v8 ad=0.1421 pd=1.56 as=0.1421 ps=1.56 w=0.49 l=0.2
X266 VIN.t1639 VIN.t1638 OUT.t788 VIN.t101 sky130_fd_pr__pfet_01v8 ad=0.1421 pd=1.56 as=0.1421 ps=1.56 w=0.49 l=0.2
X267 OUT.t787 VIN.t1636 VIN.t1637 VIN.t426 sky130_fd_pr__pfet_01v8 ad=0.1421 pd=1.56 as=0.1421 ps=1.56 w=0.49 l=0.2
X268 OUT.t786 VIN.t1634 VIN.t1635 VIN.t155 sky130_fd_pr__pfet_01v8 ad=0.1421 pd=1.56 as=0.1421 ps=1.56 w=0.49 l=0.2
X269 OUT.t785 VIN.t1632 VIN.t1633 VIN.t167 sky130_fd_pr__pfet_01v8 ad=0.1421 pd=1.56 as=0.1421 ps=1.56 w=0.49 l=0.2
X270 OUT.t784 VIN.t1630 VIN.t1631 VIN.t278 sky130_fd_pr__pfet_01v8 ad=0.1421 pd=1.56 as=0.1421 ps=1.56 w=0.49 l=0.2
X271 OUT.t783 VIN.t1628 VIN.t1629 VIN.t138 sky130_fd_pr__pfet_01v8 ad=0.1421 pd=1.56 as=0.1421 ps=1.56 w=0.49 l=0.2
X272 VIN.t1627 VIN.t1626 OUT.t782 VIN.t37 sky130_fd_pr__pfet_01v8 ad=0.1421 pd=1.56 as=0.1421 ps=1.56 w=0.49 l=0.2
X273 VIN.t1625 VIN.t1624 OUT.t781 VIN.t313 sky130_fd_pr__pfet_01v8 ad=0.1421 pd=1.56 as=0.1421 ps=1.56 w=0.49 l=0.2
X274 OUT.t780 VIN.t1622 VIN.t1623 VIN.t108 sky130_fd_pr__pfet_01v8 ad=0.1421 pd=1.56 as=0.1421 ps=1.56 w=0.49 l=0.2
X275 VIN.t1621 VIN.t1620 OUT.t779 VIN.t28 sky130_fd_pr__pfet_01v8 ad=0.1421 pd=1.56 as=0.1421 ps=1.56 w=0.49 l=0.2
X276 VIN.t1619 VIN.t1618 OUT.t778 VIN.t10 sky130_fd_pr__pfet_01v8 ad=0.1421 pd=1.56 as=0.1421 ps=1.56 w=0.49 l=0.2
X277 VIN.t1617 VIN.t1616 OUT.t777 VIN.t178 sky130_fd_pr__pfet_01v8 ad=0.1421 pd=1.56 as=0.1421 ps=1.56 w=0.49 l=0.2
X278 OUT.t776 VIN.t1614 VIN.t1615 VIN.t52 sky130_fd_pr__pfet_01v8 ad=0.1421 pd=1.56 as=0.1421 ps=1.56 w=0.49 l=0.2
X279 OUT.t775 VIN.t1612 VIN.t1613 VIN.t306 sky130_fd_pr__pfet_01v8 ad=0.1421 pd=1.56 as=0.1421 ps=1.56 w=0.49 l=0.2
X280 OUT.t774 VIN.t1610 VIN.t1611 VIN.t301 sky130_fd_pr__pfet_01v8 ad=0.1421 pd=1.56 as=0.1421 ps=1.56 w=0.49 l=0.2
X281 VIN.t1609 VIN.t1608 OUT.t773 VIN.t130 sky130_fd_pr__pfet_01v8 ad=0.1421 pd=1.56 as=0.1421 ps=1.56 w=0.49 l=0.2
X282 VIN.t1607 VIN.t1606 OUT.t772 VIN.t92 sky130_fd_pr__pfet_01v8 ad=0.1421 pd=1.56 as=0.1421 ps=1.56 w=0.49 l=0.2
X283 VIN.t1605 VIN.t1604 OUT.t771 VIN.t101 sky130_fd_pr__pfet_01v8 ad=0.1421 pd=1.56 as=0.1421 ps=1.56 w=0.49 l=0.2
X284 VIN.t1603 VIN.t1602 OUT.t770 VIN.t82 sky130_fd_pr__pfet_01v8 ad=0.1421 pd=1.56 as=0.1421 ps=1.56 w=0.49 l=0.2
X285 VIN.t1601 VIN.t1600 OUT.t769 VIN.t124 sky130_fd_pr__pfet_01v8 ad=0.1421 pd=1.56 as=0.1421 ps=1.56 w=0.49 l=0.2
X286 VIN.t1599 VIN.t1598 OUT.t768 VIN.t75 sky130_fd_pr__pfet_01v8 ad=0.1421 pd=1.56 as=0.1421 ps=1.56 w=0.49 l=0.2
X287 OUT.t767 VIN.t1596 VIN.t1597 VIN.t269 sky130_fd_pr__pfet_01v8 ad=0.1421 pd=1.56 as=0.1421 ps=1.56 w=0.49 l=0.2
X288 VIN.t1595 VIN.t1594 OUT.t766 VIN.t95 sky130_fd_pr__pfet_01v8 ad=0.1421 pd=1.56 as=0.1421 ps=1.56 w=0.49 l=0.2
X289 VIN.t1593 VIN.t1592 OUT.t765 VIN.t233 sky130_fd_pr__pfet_01v8 ad=0.1421 pd=1.56 as=0.1421 ps=1.56 w=0.49 l=0.2
X290 VIN.t1591 VIN.t1590 OUT.t764 VIN.t63 sky130_fd_pr__pfet_01v8 ad=0.1421 pd=1.56 as=0.1421 ps=1.56 w=0.49 l=0.2
X291 VIN.t1589 VIN.t1588 OUT.t763 VIN.t55 sky130_fd_pr__pfet_01v8 ad=0.1421 pd=1.56 as=0.1421 ps=1.56 w=0.49 l=0.2
X292 a_1500_2480# a_1100_700# VSS.t90 sky130_fd_pr__res_xhigh_po_0p69 l=6.9
X293 OUT.t762 VIN.t1586 VIN.t1587 VIN.t278 sky130_fd_pr__pfet_01v8 ad=0.1421 pd=1.56 as=0.1421 ps=1.56 w=0.49 l=0.2
X294 VIN.t1585 VIN.t1584 OUT.t761 VIN.t66 sky130_fd_pr__pfet_01v8 ad=0.1421 pd=1.56 as=0.1421 ps=1.56 w=0.49 l=0.2
X295 OUT.t760 VIN.t1582 VIN.t1583 VIN.t58 sky130_fd_pr__pfet_01v8 ad=0.1421 pd=1.56 as=0.1421 ps=1.56 w=0.49 l=0.2
X296 OUT.t759 VIN.t1580 VIN.t1581 VIN.t69 sky130_fd_pr__pfet_01v8 ad=0.1421 pd=1.56 as=0.1421 ps=1.56 w=0.49 l=0.2
X297 OUT.t758 VIN.t1578 VIN.t1579 VIN.t269 sky130_fd_pr__pfet_01v8 ad=0.1421 pd=1.56 as=0.1421 ps=1.56 w=0.49 l=0.2
X298 VIN.t1577 VIN.t1576 OUT.t757 VIN.t92 sky130_fd_pr__pfet_01v8 ad=0.1421 pd=1.56 as=0.1421 ps=1.56 w=0.49 l=0.2
X299 OUT.t756 VIN.t1574 VIN.t1575 VIN.t7 sky130_fd_pr__pfet_01v8 ad=0.1421 pd=1.56 as=0.1421 ps=1.56 w=0.49 l=0.2
X300 VIN.t1573 VIN.t1572 OUT.t755 VIN.t49 sky130_fd_pr__pfet_01v8 ad=0.1421 pd=1.56 as=0.1421 ps=1.56 w=0.49 l=0.2
X301 OUT.t754 VIN.t1570 VIN.t1571 VIN.t52 sky130_fd_pr__pfet_01v8 ad=0.1421 pd=1.56 as=0.1421 ps=1.56 w=0.49 l=0.2
X302 VIN.t1569 VIN.t1568 OUT.t753 VIN.t49 sky130_fd_pr__pfet_01v8 ad=0.1421 pd=1.56 as=0.1421 ps=1.56 w=0.49 l=0.2
X303 VIN.t1567 VIN.t1566 OUT.t752 VIN.t82 sky130_fd_pr__pfet_01v8 ad=0.1421 pd=1.56 as=0.1421 ps=1.56 w=0.49 l=0.2
X304 VIN.t1565 VIN.t1564 OUT.t751 VIN.t135 sky130_fd_pr__pfet_01v8 ad=0.1421 pd=1.56 as=0.1421 ps=1.56 w=0.49 l=0.2
X305 OUT.t750 VIN.t1562 VIN.t1563 VIN.t269 sky130_fd_pr__pfet_01v8 ad=0.1421 pd=1.56 as=0.1421 ps=1.56 w=0.49 l=0.2
X306 VIN.t1561 VIN.t1560 OUT.t749 VIN.t144 sky130_fd_pr__pfet_01v8 ad=0.1421 pd=1.56 as=0.1421 ps=1.56 w=0.49 l=0.2
X307 VIN.t1559 VIN.t1558 OUT.t748 VIN.t95 sky130_fd_pr__pfet_01v8 ad=0.1421 pd=1.56 as=0.1421 ps=1.56 w=0.49 l=0.2
X308 OUT.t747 VIN.t1556 VIN.t1557 VIN.t13 sky130_fd_pr__pfet_01v8 ad=0.1421 pd=1.56 as=0.1421 ps=1.56 w=0.49 l=0.2
X309 OUT.t746 VIN.t1554 VIN.t1555 VIN.t69 sky130_fd_pr__pfet_01v8 ad=0.1421 pd=1.56 as=0.1421 ps=1.56 w=0.49 l=0.2
X310 VIN.t1553 VIN.t1552 OUT.t745 VIN.t233 sky130_fd_pr__pfet_01v8 ad=0.1421 pd=1.56 as=0.1421 ps=1.56 w=0.49 l=0.2
X311 OUT.t744 VIN.t1550 VIN.t1551 VIN.t16 sky130_fd_pr__pfet_01v8 ad=0.1421 pd=1.56 as=0.1421 ps=1.56 w=0.49 l=0.2
X312 VIN.t1549 VIN.t1548 OUT.t743 VIN.t240 sky130_fd_pr__pfet_01v8 ad=0.1421 pd=1.56 as=0.1421 ps=1.56 w=0.49 l=0.2
X313 VIN.t1547 VIN.t1546 OUT.t742 VIN.t25 sky130_fd_pr__pfet_01v8 ad=0.1421 pd=1.56 as=0.1421 ps=1.56 w=0.49 l=0.2
X314 OUT.t741 VIN.t1544 VIN.t1545 VIN.t22 sky130_fd_pr__pfet_01v8 ad=0.1421 pd=1.56 as=0.1421 ps=1.56 w=0.49 l=0.2
X315 OUT.t740 VIN.t1542 VIN.t1543 VIN.t1 sky130_fd_pr__pfet_01v8 ad=0.1421 pd=1.56 as=0.1421 ps=1.56 w=0.49 l=0.2
X316 OUT.t739 VIN.t1540 VIN.t1541 VIN.t324 sky130_fd_pr__pfet_01v8 ad=0.1421 pd=1.56 as=0.1421 ps=1.56 w=0.49 l=0.2
X317 VIN.t1539 VIN.t1538 OUT.t738 VIN.t161 sky130_fd_pr__pfet_01v8 ad=0.1421 pd=1.56 as=0.1421 ps=1.56 w=0.49 l=0.2
X318 VSS.t40 bias-network_0.VREF.t6 bias-network_0.VREF.t7 VSS.t38 sky130_fd_pr__nfet_01v8 ad=0.10875 pd=1.04 as=0.2175 ps=2.08 w=0.75 l=2
X319 VIN.t1537 VIN.t1536 OUT.t737 VIN.t228 sky130_fd_pr__pfet_01v8 ad=0.1421 pd=1.56 as=0.1421 ps=1.56 w=0.49 l=0.2
X320 OUT.t736 VIN.t1534 VIN.t1535 VIN.t34 sky130_fd_pr__pfet_01v8 ad=0.1421 pd=1.56 as=0.1421 ps=1.56 w=0.49 l=0.2
X321 OUT.t735 VIN.t1532 VIN.t1533 VIN.t22 sky130_fd_pr__pfet_01v8 ad=0.1421 pd=1.56 as=0.1421 ps=1.56 w=0.49 l=0.2
X322 a_11352_2090# a_11552_310# VSS.t91 sky130_fd_pr__res_xhigh_po_0p69 l=6.9
X323 VIN.t1531 VIN.t1530 OUT.t734 VIN.t211 sky130_fd_pr__pfet_01v8 ad=0.1421 pd=1.56 as=0.1421 ps=1.56 w=0.49 l=0.2
X324 VSS.t39 bias-network_0.VREF.t4 bias-network_0.VREF.t5 VSS.t38 sky130_fd_pr__nfet_01v8 ad=0.10875 pd=1.04 as=0.2175 ps=2.08 w=0.75 l=2
X325 OUT.t733 VIN.t1528 VIN.t1529 VIN.t16 sky130_fd_pr__pfet_01v8 ad=0.1421 pd=1.56 as=0.1421 ps=1.56 w=0.49 l=0.2
X326 OUT.t732 VIN.t1526 VIN.t1527 VIN.t13 sky130_fd_pr__pfet_01v8 ad=0.1421 pd=1.56 as=0.1421 ps=1.56 w=0.49 l=0.2
X327 VIN.t1525 VIN.t1524 OUT.t731 VIN.t82 sky130_fd_pr__pfet_01v8 ad=0.1421 pd=1.56 as=0.1421 ps=1.56 w=0.49 l=0.2
X328 a_1500_2480# a_1900_700# VSS.t92 sky130_fd_pr__res_xhigh_po_0p69 l=6.9
X329 VIN.t1523 VIN.t1522 OUT.t730 VIN.t190 sky130_fd_pr__pfet_01v8 ad=0.1421 pd=1.56 as=0.1421 ps=1.56 w=0.49 l=0.2
X330 OUT.t729 VIN.t1520 VIN.t1521 VIN.t4 sky130_fd_pr__pfet_01v8 ad=0.1421 pd=1.56 as=0.1421 ps=1.56 w=0.49 l=0.2
X331 OUT.t728 VIN.t1518 VIN.t1519 VIN.t141 sky130_fd_pr__pfet_01v8 ad=0.1421 pd=1.56 as=0.1421 ps=1.56 w=0.49 l=0.2
X332 VIN.t1517 VIN.t1516 OUT.t727 VIN.t75 sky130_fd_pr__pfet_01v8 ad=0.1421 pd=1.56 as=0.1421 ps=1.56 w=0.49 l=0.2
X333 OUT.t726 VIN.t1514 VIN.t1515 VIN.t324 sky130_fd_pr__pfet_01v8 ad=0.1421 pd=1.56 as=0.1421 ps=1.56 w=0.49 l=0.2
X334 a_3816_4748.t3 bias-network_0.IBIAS1.t29 VIN.t2148 VIN.t2134 sky130_fd_pr__pfet_01v8 ad=0.23925 pd=1.94 as=0.23925 ps=1.94 w=1.65 l=0.6
X335 OUT.t725 VIN.t1512 VIN.t1513 VIN.t158 sky130_fd_pr__pfet_01v8 ad=0.1421 pd=1.56 as=0.1421 ps=1.56 w=0.49 l=0.2
X336 VIN.t1511 VIN.t1510 OUT.t724 VIN.t161 sky130_fd_pr__pfet_01v8 ad=0.1421 pd=1.56 as=0.1421 ps=1.56 w=0.49 l=0.2
X337 OUT.t1026 VIN.t2153 sky130_fd_pr__cap_mim_m3_1 l=6 w=6
X338 OUT.t723 VIN.t1508 VIN.t1509 VIN.t164 sky130_fd_pr__pfet_01v8 ad=0.1421 pd=1.56 as=0.1421 ps=1.56 w=0.49 l=0.2
X339 VIN.t1507 VIN.t1506 OUT.t722 VIN.t46 sky130_fd_pr__pfet_01v8 ad=0.1421 pd=1.56 as=0.1421 ps=1.56 w=0.49 l=0.2
X340 OUT.t721 VIN.t1504 VIN.t1505 VIN.t138 sky130_fd_pr__pfet_01v8 ad=0.1421 pd=1.56 as=0.1421 ps=1.56 w=0.49 l=0.2
X341 a_638_4130.t2 error-amplifier_0.VN a_816_4748.t6 VIN.t2114 sky130_fd_pr__pfet_01v8 ad=2.03 pd=14.58 as=1.015 ps=7.29 w=7 l=0.6
X342 OUT.t720 VIN.t1502 VIN.t1503 VIN.t278 sky130_fd_pr__pfet_01v8 ad=0.1421 pd=1.56 as=0.1421 ps=1.56 w=0.49 l=0.2
X343 VIN.t1501 VIN.t1500 OUT.t719 VIN.t25 sky130_fd_pr__pfet_01v8 ad=0.1421 pd=1.56 as=0.1421 ps=1.56 w=0.49 l=0.2
X344 OUT.t718 VIN.t1498 VIN.t1499 VIN.t185 sky130_fd_pr__pfet_01v8 ad=0.1421 pd=1.56 as=0.1421 ps=1.56 w=0.49 l=0.2
X345 VIN.t1497 VIN.t1496 OUT.t717 VIN.t190 sky130_fd_pr__pfet_01v8 ad=0.1421 pd=1.56 as=0.1421 ps=1.56 w=0.49 l=0.2
X346 OUT.t716 VIN.t1494 VIN.t1495 VIN.t31 sky130_fd_pr__pfet_01v8 ad=0.1421 pd=1.56 as=0.1421 ps=1.56 w=0.49 l=0.2
X347 VIN.t1493 VIN.t1492 OUT.t715 VIN.t178 sky130_fd_pr__pfet_01v8 ad=0.1421 pd=1.56 as=0.1421 ps=1.56 w=0.49 l=0.2
X348 VIN.t1491 VIN.t1490 OUT.t714 VIN.t178 sky130_fd_pr__pfet_01v8 ad=0.1421 pd=1.56 as=0.1421 ps=1.56 w=0.49 l=0.2
X349 OUT.t713 VIN.t1488 VIN.t1489 VIN.t4 sky130_fd_pr__pfet_01v8 ad=0.1421 pd=1.56 as=0.1421 ps=1.56 w=0.49 l=0.2
X350 OUT.t712 VIN.t1486 VIN.t1487 VIN.t301 sky130_fd_pr__pfet_01v8 ad=0.1421 pd=1.56 as=0.1421 ps=1.56 w=0.49 l=0.2
X351 VSS.t112 a_638_4130.t13 bias-network_0.IBIAS1.t13 VSS.t111 sky130_fd_pr__nfet_01v8 ad=0.15225 pd=1.34 as=0.15225 ps=1.34 w=1.05 l=0.6
X352 VIN.t1485 VIN.t1484 OUT.t711 VIN.t25 sky130_fd_pr__pfet_01v8 ad=0.1421 pd=1.56 as=0.1421 ps=1.56 w=0.49 l=0.2
X353 VIN.t1483 VIN.t1482 OUT.t710 VIN.t66 sky130_fd_pr__pfet_01v8 ad=0.1421 pd=1.56 as=0.1421 ps=1.56 w=0.49 l=0.2
X354 OUT.t709 VIN.t1480 VIN.t1481 VIN.t158 sky130_fd_pr__pfet_01v8 ad=0.1421 pd=1.56 as=0.1421 ps=1.56 w=0.49 l=0.2
X355 OUT.t708 VIN.t1478 VIN.t1479 VIN.t155 sky130_fd_pr__pfet_01v8 ad=0.1421 pd=1.56 as=0.1421 ps=1.56 w=0.49 l=0.2
X356 OUT.t707 VIN.t1476 VIN.t1477 VIN.t185 sky130_fd_pr__pfet_01v8 ad=0.1421 pd=1.56 as=0.1421 ps=1.56 w=0.49 l=0.2
X357 VIN.t1475 VIN.t1474 OUT.t706 VIN.t178 sky130_fd_pr__pfet_01v8 ad=0.1421 pd=1.56 as=0.1421 ps=1.56 w=0.49 l=0.2
X358 OUT.t705 VIN.t1472 VIN.t1473 VIN.t119 sky130_fd_pr__pfet_01v8 ad=0.1421 pd=1.56 as=0.1421 ps=1.56 w=0.49 l=0.2
X359 VIN.t1471 VIN.t1470 OUT.t704 VIN.t101 sky130_fd_pr__pfet_01v8 ad=0.1421 pd=1.56 as=0.1421 ps=1.56 w=0.49 l=0.2
X360 OUT.t703 VIN.t1468 VIN.t1469 VIN.t141 sky130_fd_pr__pfet_01v8 ad=0.1421 pd=1.56 as=0.1421 ps=1.56 w=0.49 l=0.2
X361 OUT.t702 VIN.t1466 VIN.t1467 VIN.t138 sky130_fd_pr__pfet_01v8 ad=0.1421 pd=1.56 as=0.1421 ps=1.56 w=0.49 l=0.2
X362 OUT.t701 VIN.t1464 VIN.t1465 VIN.t155 sky130_fd_pr__pfet_01v8 ad=0.1421 pd=1.56 as=0.1421 ps=1.56 w=0.49 l=0.2
X363 VIN.t1463 VIN.t1462 OUT.t700 VIN.t116 sky130_fd_pr__pfet_01v8 ad=0.1421 pd=1.56 as=0.1421 ps=1.56 w=0.49 l=0.2
X364 VIN.t1461 VIN.t1460 OUT.t699 VIN.t135 sky130_fd_pr__pfet_01v8 ad=0.1421 pd=1.56 as=0.1421 ps=1.56 w=0.49 l=0.2
X365 VIN.t1459 VIN.t1458 OUT.t698 VIN.t161 sky130_fd_pr__pfet_01v8 ad=0.1421 pd=1.56 as=0.1421 ps=1.56 w=0.49 l=0.2
X366 VIN.t1457 VIN.t1456 OUT.t697 VIN.t124 sky130_fd_pr__pfet_01v8 ad=0.1421 pd=1.56 as=0.1421 ps=1.56 w=0.49 l=0.2
X367 OUT.t696 VIN.t1454 VIN.t1455 VIN.t119 sky130_fd_pr__pfet_01v8 ad=0.1421 pd=1.56 as=0.1421 ps=1.56 w=0.49 l=0.2
X368 a_3816_4748.t6 bias-network_0.IBIAS1.t30 a_3638_4130.t2 VIN.t2140 sky130_fd_pr__pfet_01v8 ad=1.015 pd=7.29 as=2.03 ps=14.58 w=7 l=0.6
X369 OUT.t695 VIN.t1452 VIN.t1453 VIN.t108 sky130_fd_pr__pfet_01v8 ad=0.1421 pd=1.56 as=0.1421 ps=1.56 w=0.49 l=0.2
X370 bias-network_0.IBIAS2.t15 bias-network_0.IBIAS2.t14 VIN.t2119 VIN.t2113 sky130_fd_pr__pfet_01v8 ad=0.23925 pd=1.94 as=0.23925 ps=1.94 w=1.65 l=0.6
X371 VIN.t1451 VIN.t1450 OUT.t694 VIN.t395 sky130_fd_pr__pfet_01v8 ad=0.1421 pd=1.56 as=0.1421 ps=1.56 w=0.49 l=0.2
X372 a_10952_2090# a_10752_310# VSS.t93 sky130_fd_pr__res_xhigh_po_0p69 l=6.9
X373 OUT.t693 VIN.t1448 VIN.t1449 VIN.t98 sky130_fd_pr__pfet_01v8 ad=0.1421 pd=1.56 as=0.1421 ps=1.56 w=0.49 l=0.2
X374 VIN.t1447 VIN.t1446 OUT.t692 VIN.t95 sky130_fd_pr__pfet_01v8 ad=0.1421 pd=1.56 as=0.1421 ps=1.56 w=0.49 l=0.2
X375 VIN.t1445 VIN.t1444 OUT.t691 VIN.t124 sky130_fd_pr__pfet_01v8 ad=0.1421 pd=1.56 as=0.1421 ps=1.56 w=0.49 l=0.2
X376 VIN.t1443 VIN.t1442 OUT.t690 VIN.t101 sky130_fd_pr__pfet_01v8 ad=0.1421 pd=1.56 as=0.1421 ps=1.56 w=0.49 l=0.2
X377 OUT.t689 VIN.t1440 VIN.t1441 VIN.t138 sky130_fd_pr__pfet_01v8 ad=0.1421 pd=1.56 as=0.1421 ps=1.56 w=0.49 l=0.2
X378 OUT.t688 VIN.t1438 VIN.t1439 VIN.t13 sky130_fd_pr__pfet_01v8 ad=0.1421 pd=1.56 as=0.1421 ps=1.56 w=0.49 l=0.2
X379 VIN.t1437 VIN.t1436 OUT.t687 VIN.t228 sky130_fd_pr__pfet_01v8 ad=0.1421 pd=1.56 as=0.1421 ps=1.56 w=0.49 l=0.2
X380 VIN.t1435 VIN.t1434 OUT.t686 VIN.t75 sky130_fd_pr__pfet_01v8 ad=0.1421 pd=1.56 as=0.1421 ps=1.56 w=0.49 l=0.2
X381 VIN.t1433 VIN.t1432 OUT.t685 VIN.t395 sky130_fd_pr__pfet_01v8 ad=0.1421 pd=1.56 as=0.1421 ps=1.56 w=0.49 l=0.2
X382 OUT.t684 VIN.t1430 VIN.t1431 VIN.t69 sky130_fd_pr__pfet_01v8 ad=0.1421 pd=1.56 as=0.1421 ps=1.56 w=0.49 l=0.2
X383 VIN.t1429 VIN.t1428 OUT.t683 VIN.t63 sky130_fd_pr__pfet_01v8 ad=0.1421 pd=1.56 as=0.1421 ps=1.56 w=0.49 l=0.2
X384 OUT.t682 VIN.t1426 VIN.t1427 VIN.t43 sky130_fd_pr__pfet_01v8 ad=0.1421 pd=1.56 as=0.1421 ps=1.56 w=0.49 l=0.2
X385 VIN.t1425 VIN.t1424 OUT.t681 VIN.t66 sky130_fd_pr__pfet_01v8 ad=0.1421 pd=1.56 as=0.1421 ps=1.56 w=0.49 l=0.2
X386 OUT.t680 VIN.t1422 VIN.t1423 VIN.t87 sky130_fd_pr__pfet_01v8 ad=0.1421 pd=1.56 as=0.1421 ps=1.56 w=0.49 l=0.2
X387 OUT.t679 VIN.t1420 VIN.t1421 VIN.t58 sky130_fd_pr__pfet_01v8 ad=0.1421 pd=1.56 as=0.1421 ps=1.56 w=0.49 l=0.2
X388 VIN.t1419 VIN.t1418 OUT.t678 VIN.t55 sky130_fd_pr__pfet_01v8 ad=0.1421 pd=1.56 as=0.1421 ps=1.56 w=0.49 l=0.2
X389 VIN.t1417 VIN.t1416 OUT.t677 VIN.t313 sky130_fd_pr__pfet_01v8 ad=0.1421 pd=1.56 as=0.1421 ps=1.56 w=0.49 l=0.2
X390 VIN.t1415 VIN.t1414 OUT.t676 VIN.t49 sky130_fd_pr__pfet_01v8 ad=0.1421 pd=1.56 as=0.1421 ps=1.56 w=0.49 l=0.2
X391 OUT.t675 VIN.t1412 VIN.t1413 VIN.t52 sky130_fd_pr__pfet_01v8 ad=0.1421 pd=1.56 as=0.1421 ps=1.56 w=0.49 l=0.2
X392 bias-network_0.IBIAS1.t20 bias-network_0.VREF.t21 VSS.t37 VSS.t26 sky130_fd_pr__nfet_01v8 ad=0.10875 pd=1.04 as=0.10875 ps=1.04 w=0.75 l=2
X393 VIN.t1411 VIN.t1410 OUT.t674 VIN.t46 sky130_fd_pr__pfet_01v8 ad=0.1421 pd=1.56 as=0.1421 ps=1.56 w=0.49 l=0.2
X394 VIN.t1409 VIN.t1408 OUT.t673 VIN.t127 sky130_fd_pr__pfet_01v8 ad=0.1421 pd=1.56 as=0.1421 ps=1.56 w=0.49 l=0.2
X395 OUT.t1027 bias-network_0.IBIAS1.t11 sky130_fd_pr__cap_mim_m3_1 l=6 w=6
X396 VIN.t1407 VIN.t1406 OUT.t672 VIN.t40 sky130_fd_pr__pfet_01v8 ad=0.1421 pd=1.56 as=0.1421 ps=1.56 w=0.49 l=0.2
X397 OUT.t671 VIN.t1404 VIN.t1405 VIN.t31 sky130_fd_pr__pfet_01v8 ad=0.1421 pd=1.56 as=0.1421 ps=1.56 w=0.49 l=0.2
X398 VIN.t1403 VIN.t1402 OUT.t670 VIN.t228 sky130_fd_pr__pfet_01v8 ad=0.1421 pd=1.56 as=0.1421 ps=1.56 w=0.49 l=0.2
X399 OUT.t669 VIN.t1400 VIN.t1401 VIN.t19 sky130_fd_pr__pfet_01v8 ad=0.1421 pd=1.56 as=0.1421 ps=1.56 w=0.49 l=0.2
X400 VSS.t52 VSS.t53 VSS.t51 sky130_fd_pr__res_xhigh_po_0p69 l=6.9
X401 VIN.t1399 VIN.t1398 OUT.t668 VIN.t25 sky130_fd_pr__pfet_01v8 ad=0.1421 pd=1.56 as=0.1421 ps=1.56 w=0.49 l=0.2
X402 OUT.t667 VIN.t1396 VIN.t1397 VIN.t22 sky130_fd_pr__pfet_01v8 ad=0.1421 pd=1.56 as=0.1421 ps=1.56 w=0.49 l=0.2
X403 bias-network_0.IBIAS1.t21 bias-network_0.VREF.t22 VSS.t36 VSS.t26 sky130_fd_pr__nfet_01v8 ad=0.10875 pd=1.04 as=0.10875 ps=1.04 w=0.75 l=2
X404 OUT.t666 VIN.t1394 VIN.t1395 VIN.t1 sky130_fd_pr__pfet_01v8 ad=0.1421 pd=1.56 as=0.1421 ps=1.56 w=0.49 l=0.2
X405 OUT.t665 VIN.t1392 VIN.t1393 VIN.t339 sky130_fd_pr__pfet_01v8 ad=0.1421 pd=1.56 as=0.1421 ps=1.56 w=0.49 l=0.2
X406 OUT.t664 VIN.t1390 VIN.t1391 VIN.t34 sky130_fd_pr__pfet_01v8 ad=0.1421 pd=1.56 as=0.1421 ps=1.56 w=0.49 l=0.2
X407 VIN.t1389 VIN.t1388 OUT.t663 VIN.t10 sky130_fd_pr__pfet_01v8 ad=0.1421 pd=1.56 as=0.1421 ps=1.56 w=0.49 l=0.2
X408 VIN.t1387 VIN.t1386 OUT.t662 VIN.t37 sky130_fd_pr__pfet_01v8 ad=0.1421 pd=1.56 as=0.1421 ps=1.56 w=0.49 l=0.2
X409 OUT.t661 VIN.t1384 VIN.t1385 VIN.t22 sky130_fd_pr__pfet_01v8 ad=0.1421 pd=1.56 as=0.1421 ps=1.56 w=0.49 l=0.2
X410 OUT.t660 VIN.t1382 VIN.t1383 VIN.t141 sky130_fd_pr__pfet_01v8 ad=0.1421 pd=1.56 as=0.1421 ps=1.56 w=0.49 l=0.2
X411 VIN.t1381 VIN.t1380 OUT.t659 VIN.t240 sky130_fd_pr__pfet_01v8 ad=0.1421 pd=1.56 as=0.1421 ps=1.56 w=0.49 l=0.2
X412 VIN.t1379 VIN.t1378 OUT.t658 VIN.t313 sky130_fd_pr__pfet_01v8 ad=0.1421 pd=1.56 as=0.1421 ps=1.56 w=0.49 l=0.2
X413 VIN.t1377 VIN.t1376 OUT.t657 VIN.t10 sky130_fd_pr__pfet_01v8 ad=0.1421 pd=1.56 as=0.1421 ps=1.56 w=0.49 l=0.2
X414 OUT.t656 VIN.t1374 VIN.t1375 VIN.t119 sky130_fd_pr__pfet_01v8 ad=0.1421 pd=1.56 as=0.1421 ps=1.56 w=0.49 l=0.2
X415 OUT.t655 VIN.t1372 VIN.t1373 VIN.t1 sky130_fd_pr__pfet_01v8 ad=0.1421 pd=1.56 as=0.1421 ps=1.56 w=0.49 l=0.2
X416 OUT.t654 VIN.t1370 VIN.t1371 VIN.t301 sky130_fd_pr__pfet_01v8 ad=0.1421 pd=1.56 as=0.1421 ps=1.56 w=0.49 l=0.2
X417 VIN.t1369 VIN.t1368 OUT.t653 VIN.t130 sky130_fd_pr__pfet_01v8 ad=0.1421 pd=1.56 as=0.1421 ps=1.56 w=0.49 l=0.2
X418 OUT.t652 VIN.t1366 VIN.t1367 VIN.t278 sky130_fd_pr__pfet_01v8 ad=0.1421 pd=1.56 as=0.1421 ps=1.56 w=0.49 l=0.2
X419 OUT.t651 VIN.t1364 VIN.t1365 VIN.t164 sky130_fd_pr__pfet_01v8 ad=0.1421 pd=1.56 as=0.1421 ps=1.56 w=0.49 l=0.2
X420 OUT.t650 VIN.t1362 VIN.t1363 VIN.t158 sky130_fd_pr__pfet_01v8 ad=0.1421 pd=1.56 as=0.1421 ps=1.56 w=0.49 l=0.2
X421 VIN.t1361 VIN.t1360 OUT.t649 VIN.t127 sky130_fd_pr__pfet_01v8 ad=0.1421 pd=1.56 as=0.1421 ps=1.56 w=0.49 l=0.2
X422 VIN.t1359 VIN.t1358 OUT.t648 VIN.t190 sky130_fd_pr__pfet_01v8 ad=0.1421 pd=1.56 as=0.1421 ps=1.56 w=0.49 l=0.2
X423 OUT.t647 VIN.t1356 VIN.t1357 VIN.t167 sky130_fd_pr__pfet_01v8 ad=0.1421 pd=1.56 as=0.1421 ps=1.56 w=0.49 l=0.2
X424 OUT.t646 VIN.t1354 VIN.t1355 VIN.t31 sky130_fd_pr__pfet_01v8 ad=0.1421 pd=1.56 as=0.1421 ps=1.56 w=0.49 l=0.2
X425 VIN.t1353 VIN.t1352 OUT.t645 VIN.t178 sky130_fd_pr__pfet_01v8 ad=0.1421 pd=1.56 as=0.1421 ps=1.56 w=0.49 l=0.2
X426 OUT.t1028 bias-network_0.IBIAS1.t10 sky130_fd_pr__cap_mim_m3_1 l=6 w=6
X427 OUT.t644 VIN.t1350 VIN.t1351 VIN.t301 sky130_fd_pr__pfet_01v8 ad=0.1421 pd=1.56 as=0.1421 ps=1.56 w=0.49 l=0.2
X428 OUT.t643 VIN.t1348 VIN.t1349 VIN.t278 sky130_fd_pr__pfet_01v8 ad=0.1421 pd=1.56 as=0.1421 ps=1.56 w=0.49 l=0.2
X429 OUT.t642 VIN.t1346 VIN.t1347 VIN.t119 sky130_fd_pr__pfet_01v8 ad=0.1421 pd=1.56 as=0.1421 ps=1.56 w=0.49 l=0.2
X430 VIN.t1345 VIN.t1344 OUT.t641 VIN.t101 sky130_fd_pr__pfet_01v8 ad=0.1421 pd=1.56 as=0.1421 ps=1.56 w=0.49 l=0.2
X431 OUT.t640 VIN.t1342 VIN.t1343 VIN.t34 sky130_fd_pr__pfet_01v8 ad=0.1421 pd=1.56 as=0.1421 ps=1.56 w=0.49 l=0.2
X432 OUT.t639 VIN.t1340 VIN.t1341 VIN.t158 sky130_fd_pr__pfet_01v8 ad=0.1421 pd=1.56 as=0.1421 ps=1.56 w=0.49 l=0.2
X433 OUT.t638 VIN.t1338 VIN.t1339 VIN.t72 sky130_fd_pr__pfet_01v8 ad=0.1421 pd=1.56 as=0.1421 ps=1.56 w=0.49 l=0.2
X434 OUT.t637 VIN.t1336 VIN.t1337 VIN.t185 sky130_fd_pr__pfet_01v8 ad=0.1421 pd=1.56 as=0.1421 ps=1.56 w=0.49 l=0.2
X435 a_9352_2090# a_9152_310# VSS.t54 sky130_fd_pr__res_xhigh_po_0p69 l=6.9
X436 VIN.t1335 VIN.t1334 OUT.t636 VIN.t130 sky130_fd_pr__pfet_01v8 ad=0.1421 pd=1.56 as=0.1421 ps=1.56 w=0.49 l=0.2
X437 OUT.t635 VIN.t1332 VIN.t1333 VIN.t426 sky130_fd_pr__pfet_01v8 ad=0.1421 pd=1.56 as=0.1421 ps=1.56 w=0.49 l=0.2
X438 OUT.t634 VIN.t1330 VIN.t1331 VIN.t7 sky130_fd_pr__pfet_01v8 ad=0.1421 pd=1.56 as=0.1421 ps=1.56 w=0.49 l=0.2
X439 VIN.t1329 VIN.t1328 OUT.t633 VIN.t49 sky130_fd_pr__pfet_01v8 ad=0.1421 pd=1.56 as=0.1421 ps=1.56 w=0.49 l=0.2
X440 a_3816_4748.t8 bias-network_0.VREF.t23 VIN.t2133 VIN.t2132 sky130_fd_pr__pfet_01v8 ad=1.015 pd=7.29 as=1.015 ps=7.29 w=7 l=0.6
X441 OUT.t632 VIN.t1326 VIN.t1327 VIN.t339 sky130_fd_pr__pfet_01v8 ad=0.1421 pd=1.56 as=0.1421 ps=1.56 w=0.49 l=0.2
X442 VIN.t1325 VIN.t1324 OUT.t631 VIN.t395 sky130_fd_pr__pfet_01v8 ad=0.1421 pd=1.56 as=0.1421 ps=1.56 w=0.49 l=0.2
X443 VIN.t1323 VIN.t1322 OUT.t630 VIN.t144 sky130_fd_pr__pfet_01v8 ad=0.1421 pd=1.56 as=0.1421 ps=1.56 w=0.49 l=0.2
X444 VIN.t1321 VIN.t1320 OUT.t629 VIN.t101 sky130_fd_pr__pfet_01v8 ad=0.1421 pd=1.56 as=0.1421 ps=1.56 w=0.49 l=0.2
X445 VIN.t1319 VIN.t1318 OUT.t628 VIN.t135 sky130_fd_pr__pfet_01v8 ad=0.1421 pd=1.56 as=0.1421 ps=1.56 w=0.49 l=0.2
X446 OUT.t627 VIN.t1316 VIN.t1317 VIN.t119 sky130_fd_pr__pfet_01v8 ad=0.1421 pd=1.56 as=0.1421 ps=1.56 w=0.49 l=0.2
X447 VIN.t1315 VIN.t1314 OUT.t626 VIN.t101 sky130_fd_pr__pfet_01v8 ad=0.1421 pd=1.56 as=0.1421 ps=1.56 w=0.49 l=0.2
X448 OUT.t625 VIN.t1312 VIN.t1313 VIN.t52 sky130_fd_pr__pfet_01v8 ad=0.1421 pd=1.56 as=0.1421 ps=1.56 w=0.49 l=0.2
X449 VIN.t1311 VIN.t1310 OUT.t624 VIN.t161 sky130_fd_pr__pfet_01v8 ad=0.1421 pd=1.56 as=0.1421 ps=1.56 w=0.49 l=0.2
X450 OUT.t623 VIN.t1308 VIN.t1309 VIN.t108 sky130_fd_pr__pfet_01v8 ad=0.1421 pd=1.56 as=0.1421 ps=1.56 w=0.49 l=0.2
X451 OUT.t622 VIN.t1306 VIN.t1307 VIN.t43 sky130_fd_pr__pfet_01v8 ad=0.1421 pd=1.56 as=0.1421 ps=1.56 w=0.49 l=0.2
X452 VIN.t1305 VIN.t1304 OUT.t621 VIN.t395 sky130_fd_pr__pfet_01v8 ad=0.1421 pd=1.56 as=0.1421 ps=1.56 w=0.49 l=0.2
X453 VIN.t2129 a_3638_4130.t13 VSS.t11 VSS.t10 sky130_fd_pr__nfet_01v8 ad=0.15225 pd=1.34 as=0.15225 ps=1.34 w=1.05 l=0.6
X454 VIN.t1303 VIN.t1302 OUT.t620 VIN.t211 sky130_fd_pr__pfet_01v8 ad=0.1421 pd=1.56 as=0.1421 ps=1.56 w=0.49 l=0.2
X455 OUT.t619 VIN.t1300 VIN.t1301 VIN.t19 sky130_fd_pr__pfet_01v8 ad=0.1421 pd=1.56 as=0.1421 ps=1.56 w=0.49 l=0.2
X456 VIN.t1299 VIN.t1298 OUT.t618 VIN.t37 sky130_fd_pr__pfet_01v8 ad=0.1421 pd=1.56 as=0.1421 ps=1.56 w=0.49 l=0.2
X457 OUT.t617 VIN.t1296 VIN.t1297 VIN.t22 sky130_fd_pr__pfet_01v8 ad=0.1421 pd=1.56 as=0.1421 ps=1.56 w=0.49 l=0.2
X458 OUT.t616 VIN.t1294 VIN.t1295 VIN.t72 sky130_fd_pr__pfet_01v8 ad=0.1421 pd=1.56 as=0.1421 ps=1.56 w=0.49 l=0.2
X459 VIN.t1293 VIN.t1292 OUT.t615 VIN.t95 sky130_fd_pr__pfet_01v8 ad=0.1421 pd=1.56 as=0.1421 ps=1.56 w=0.49 l=0.2
X460 VIN.t1291 VIN.t1290 OUT.t614 VIN.t25 sky130_fd_pr__pfet_01v8 ad=0.1421 pd=1.56 as=0.1421 ps=1.56 w=0.49 l=0.2
X461 VIN.t2145 bias-network_0.IBIAS1.t4 bias-network_0.IBIAS1.t5 VIN.t2144 sky130_fd_pr__pfet_01v8 ad=0.23925 pd=1.94 as=0.23925 ps=1.94 w=1.65 l=0.6
X462 OUT.t613 VIN.t1288 VIN.t1289 VIN.t58 sky130_fd_pr__pfet_01v8 ad=0.1421 pd=1.56 as=0.1421 ps=1.56 w=0.49 l=0.2
X463 OUT.t612 VIN.t1286 VIN.t1287 VIN.t13 sky130_fd_pr__pfet_01v8 ad=0.1421 pd=1.56 as=0.1421 ps=1.56 w=0.49 l=0.2
X464 VIN.t1285 VIN.t1284 OUT.t611 VIN.t40 sky130_fd_pr__pfet_01v8 ad=0.1421 pd=1.56 as=0.1421 ps=1.56 w=0.49 l=0.2
X465 VIN.t1283 VIN.t1282 OUT.t610 VIN.t228 sky130_fd_pr__pfet_01v8 ad=0.1421 pd=1.56 as=0.1421 ps=1.56 w=0.49 l=0.2
X466 OUT.t609 VIN.t1280 VIN.t1281 VIN.t119 sky130_fd_pr__pfet_01v8 ad=0.1421 pd=1.56 as=0.1421 ps=1.56 w=0.49 l=0.2
X467 VIN.t1279 VIN.t1278 OUT.t608 VIN.t190 sky130_fd_pr__pfet_01v8 ad=0.1421 pd=1.56 as=0.1421 ps=1.56 w=0.49 l=0.2
X468 OUT.t607 VIN.t1276 VIN.t1277 VIN.t52 sky130_fd_pr__pfet_01v8 ad=0.1421 pd=1.56 as=0.1421 ps=1.56 w=0.49 l=0.2
X469 VIN.t1275 VIN.t1274 OUT.t606 VIN.t360 sky130_fd_pr__pfet_01v8 ad=0.1421 pd=1.56 as=0.1421 ps=1.56 w=0.49 l=0.2
X470 OUT.t605 VIN.t1272 VIN.t1273 VIN.t43 sky130_fd_pr__pfet_01v8 ad=0.1421 pd=1.56 as=0.1421 ps=1.56 w=0.49 l=0.2
X471 OUT.t604 VIN.t1270 VIN.t1271 VIN.t69 sky130_fd_pr__pfet_01v8 ad=0.1421 pd=1.56 as=0.1421 ps=1.56 w=0.49 l=0.2
X472 VIN.t1269 VIN.t1268 OUT.t603 VIN.t46 sky130_fd_pr__pfet_01v8 ad=0.1421 pd=1.56 as=0.1421 ps=1.56 w=0.49 l=0.2
X473 VIN.t1267 VIN.t1266 OUT.t602 VIN.t55 sky130_fd_pr__pfet_01v8 ad=0.1421 pd=1.56 as=0.1421 ps=1.56 w=0.49 l=0.2
X474 VIN.t1265 VIN.t1264 OUT.t601 VIN.t313 sky130_fd_pr__pfet_01v8 ad=0.1421 pd=1.56 as=0.1421 ps=1.56 w=0.49 l=0.2
X475 VIN.t2149 bias-network_0.IBIAS1.t31 a_3816_4748.t2 VIN.t2136 sky130_fd_pr__pfet_01v8 ad=0.23925 pd=1.94 as=0.23925 ps=1.94 w=1.65 l=0.6
X476 VIN.t1263 VIN.t1262 OUT.t600 VIN.t95 sky130_fd_pr__pfet_01v8 ad=0.1421 pd=1.56 as=0.1421 ps=1.56 w=0.49 l=0.2
X477 VIN.t1261 VIN.t1260 OUT.t599 VIN.t25 sky130_fd_pr__pfet_01v8 ad=0.1421 pd=1.56 as=0.1421 ps=1.56 w=0.49 l=0.2
X478 VIN.t1259 VIN.t1258 OUT.t598 VIN.t46 sky130_fd_pr__pfet_01v8 ad=0.1421 pd=1.56 as=0.1421 ps=1.56 w=0.49 l=0.2
X479 OUT.t597 VIN.t1256 VIN.t1257 VIN.t87 sky130_fd_pr__pfet_01v8 ad=0.1421 pd=1.56 as=0.1421 ps=1.56 w=0.49 l=0.2
X480 VIN.t1255 VIN.t1254 OUT.t596 VIN.t49 sky130_fd_pr__pfet_01v8 ad=0.1421 pd=1.56 as=0.1421 ps=1.56 w=0.49 l=0.2
X481 VIN.t1253 VIN.t1252 OUT.t595 VIN.t127 sky130_fd_pr__pfet_01v8 ad=0.1421 pd=1.56 as=0.1421 ps=1.56 w=0.49 l=0.2
X482 VIN.t1251 VIN.t1250 OUT.t594 VIN.t313 sky130_fd_pr__pfet_01v8 ad=0.1421 pd=1.56 as=0.1421 ps=1.56 w=0.49 l=0.2
X483 VIN.t1249 VIN.t1248 OUT.t593 VIN.t28 sky130_fd_pr__pfet_01v8 ad=0.1421 pd=1.56 as=0.1421 ps=1.56 w=0.49 l=0.2
X484 OUT.t592 VIN.t1246 VIN.t1247 VIN.t87 sky130_fd_pr__pfet_01v8 ad=0.1421 pd=1.56 as=0.1421 ps=1.56 w=0.49 l=0.2
X485 OUT.t591 VIN.t1244 VIN.t1245 VIN.t4 sky130_fd_pr__pfet_01v8 ad=0.1421 pd=1.56 as=0.1421 ps=1.56 w=0.49 l=0.2
X486 OUT.t590 VIN.t1242 VIN.t1243 VIN.t306 sky130_fd_pr__pfet_01v8 ad=0.1421 pd=1.56 as=0.1421 ps=1.56 w=0.49 l=0.2
X487 OUT.t589 VIN.t1240 VIN.t1241 VIN.t301 sky130_fd_pr__pfet_01v8 ad=0.1421 pd=1.56 as=0.1421 ps=1.56 w=0.49 l=0.2
X488 VIN.t1239 VIN.t1238 OUT.t588 VIN.t130 sky130_fd_pr__pfet_01v8 ad=0.1421 pd=1.56 as=0.1421 ps=1.56 w=0.49 l=0.2
X489 OUT.t587 VIN.t1236 VIN.t1237 VIN.t19 sky130_fd_pr__pfet_01v8 ad=0.1421 pd=1.56 as=0.1421 ps=1.56 w=0.49 l=0.2
X490 VIN.t1235 VIN.t1234 OUT.t586 VIN.t190 sky130_fd_pr__pfet_01v8 ad=0.1421 pd=1.56 as=0.1421 ps=1.56 w=0.49 l=0.2
X491 a_8532_2090# a_8752_310# VSS.t55 sky130_fd_pr__res_xhigh_po_0p69 l=6.9
X492 OUT.t585 VIN.t1232 VIN.t1233 VIN.t324 sky130_fd_pr__pfet_01v8 ad=0.1421 pd=1.56 as=0.1421 ps=1.56 w=0.49 l=0.2
X493 VIN.t1231 VIN.t1230 OUT.t584 VIN.t55 sky130_fd_pr__pfet_01v8 ad=0.1421 pd=1.56 as=0.1421 ps=1.56 w=0.49 l=0.2
X494 OUT.t583 VIN.t1228 VIN.t1229 VIN.t155 sky130_fd_pr__pfet_01v8 ad=0.1421 pd=1.56 as=0.1421 ps=1.56 w=0.49 l=0.2
X495 a_638_4130.t11 a_638_4130.t10 VSS.t108 VSS.t107 sky130_fd_pr__nfet_01v8 ad=0.15225 pd=1.34 as=0.15225 ps=1.34 w=1.05 l=0.6
X496 OUT.t582 VIN.t1226 VIN.t1227 VIN.t339 sky130_fd_pr__pfet_01v8 ad=0.1421 pd=1.56 as=0.1421 ps=1.56 w=0.49 l=0.2
X497 OUT.t581 VIN.t1224 VIN.t1225 VIN.t141 sky130_fd_pr__pfet_01v8 ad=0.1421 pd=1.56 as=0.1421 ps=1.56 w=0.49 l=0.2
X498 OUT.t580 VIN.t1222 VIN.t1223 VIN.t269 sky130_fd_pr__pfet_01v8 ad=0.1421 pd=1.56 as=0.1421 ps=1.56 w=0.49 l=0.2
X499 VIN.t1221 VIN.t1220 OUT.t579 VIN.t37 sky130_fd_pr__pfet_01v8 ad=0.1421 pd=1.56 as=0.1421 ps=1.56 w=0.49 l=0.2
X500 OUT.t578 VIN.t1218 VIN.t1219 VIN.t158 sky130_fd_pr__pfet_01v8 ad=0.1421 pd=1.56 as=0.1421 ps=1.56 w=0.49 l=0.2
X501 OUT.t577 VIN.t1216 VIN.t1217 VIN.t19 sky130_fd_pr__pfet_01v8 ad=0.1421 pd=1.56 as=0.1421 ps=1.56 w=0.49 l=0.2
X502 VIN.t1215 VIN.t1214 OUT.t576 VIN.t190 sky130_fd_pr__pfet_01v8 ad=0.1421 pd=1.56 as=0.1421 ps=1.56 w=0.49 l=0.2
X503 VIN.t1213 VIN.t1212 OUT.t575 VIN.t240 sky130_fd_pr__pfet_01v8 ad=0.1421 pd=1.56 as=0.1421 ps=1.56 w=0.49 l=0.2
X504 OUT.t574 VIN.t1210 VIN.t1211 VIN.t98 sky130_fd_pr__pfet_01v8 ad=0.1421 pd=1.56 as=0.1421 ps=1.56 w=0.49 l=0.2
X505 VIN.t1209 VIN.t1208 OUT.t573 VIN.t10 sky130_fd_pr__pfet_01v8 ad=0.1421 pd=1.56 as=0.1421 ps=1.56 w=0.49 l=0.2
X506 VIN.t1207 VIN.t1206 OUT.t572 VIN.t10 sky130_fd_pr__pfet_01v8 ad=0.1421 pd=1.56 as=0.1421 ps=1.56 w=0.49 l=0.2
X507 VIN.t1205 VIN.t1204 OUT.t571 VIN.t63 sky130_fd_pr__pfet_01v8 ad=0.1421 pd=1.56 as=0.1421 ps=1.56 w=0.49 l=0.2
X508 OUT.t570 VIN.t1202 VIN.t1203 VIN.t7 sky130_fd_pr__pfet_01v8 ad=0.1421 pd=1.56 as=0.1421 ps=1.56 w=0.49 l=0.2
X509 OUT.t569 VIN.t1200 VIN.t1201 VIN.t108 sky130_fd_pr__pfet_01v8 ad=0.1421 pd=1.56 as=0.1421 ps=1.56 w=0.49 l=0.2
X510 VIN.t1199 VIN.t1198 OUT.t568 VIN.t135 sky130_fd_pr__pfet_01v8 ad=0.1421 pd=1.56 as=0.1421 ps=1.56 w=0.49 l=0.2
X511 VIN.t1197 VIN.t1196 OUT.t567 VIN.t144 sky130_fd_pr__pfet_01v8 ad=0.1421 pd=1.56 as=0.1421 ps=1.56 w=0.49 l=0.2
X512 VIN.t1195 VIN.t1194 OUT.t566 VIN.t127 sky130_fd_pr__pfet_01v8 ad=0.1421 pd=1.56 as=0.1421 ps=1.56 w=0.49 l=0.2
X513 VIN.t1193 VIN.t1192 OUT.t565 VIN.t135 sky130_fd_pr__pfet_01v8 ad=0.1421 pd=1.56 as=0.1421 ps=1.56 w=0.49 l=0.2
X514 OUT.t564 VIN.t1190 VIN.t1191 VIN.t278 sky130_fd_pr__pfet_01v8 ad=0.1421 pd=1.56 as=0.1421 ps=1.56 w=0.49 l=0.2
X515 OUT.t563 VIN.t1188 VIN.t1189 VIN.t98 sky130_fd_pr__pfet_01v8 ad=0.1421 pd=1.56 as=0.1421 ps=1.56 w=0.49 l=0.2
X516 VIN.t1187 VIN.t1186 OUT.t562 VIN.t240 sky130_fd_pr__pfet_01v8 ad=0.1421 pd=1.56 as=0.1421 ps=1.56 w=0.49 l=0.2
X517 a_3816_4748.t1 bias-network_0.IBIAS1.t32 VIN.t2150 VIN.t2138 sky130_fd_pr__pfet_01v8 ad=0.23925 pd=1.94 as=0.23925 ps=1.94 w=1.65 l=0.6
X518 OUT.t561 VIN.t1184 VIN.t1185 VIN.t164 sky130_fd_pr__pfet_01v8 ad=0.1421 pd=1.56 as=0.1421 ps=1.56 w=0.49 l=0.2
X519 OUT.t560 VIN.t1182 VIN.t1183 VIN.t158 sky130_fd_pr__pfet_01v8 ad=0.1421 pd=1.56 as=0.1421 ps=1.56 w=0.49 l=0.2
X520 OUT.t559 VIN.t1180 VIN.t1181 VIN.t278 sky130_fd_pr__pfet_01v8 ad=0.1421 pd=1.56 as=0.1421 ps=1.56 w=0.49 l=0.2
X521 VIN.t1179 VIN.t1178 OUT.t558 VIN.t144 sky130_fd_pr__pfet_01v8 ad=0.1421 pd=1.56 as=0.1421 ps=1.56 w=0.49 l=0.2
X522 VIN.t1177 VIN.t1176 OUT.t557 VIN.t66 sky130_fd_pr__pfet_01v8 ad=0.1421 pd=1.56 as=0.1421 ps=1.56 w=0.49 l=0.2
X523 VIN.t1175 VIN.t1174 OUT.t556 VIN.t63 sky130_fd_pr__pfet_01v8 ad=0.1421 pd=1.56 as=0.1421 ps=1.56 w=0.49 l=0.2
X524 VIN.t1173 VIN.t1172 OUT.t555 VIN.t211 sky130_fd_pr__pfet_01v8 ad=0.1421 pd=1.56 as=0.1421 ps=1.56 w=0.49 l=0.2
X525 VIN.t1171 VIN.t1170 OUT.t554 VIN.t135 sky130_fd_pr__pfet_01v8 ad=0.1421 pd=1.56 as=0.1421 ps=1.56 w=0.49 l=0.2
X526 OUT.t553 VIN.t1168 VIN.t1169 VIN.t13 sky130_fd_pr__pfet_01v8 ad=0.1421 pd=1.56 as=0.1421 ps=1.56 w=0.49 l=0.2
X527 VIN.t1167 VIN.t1166 OUT.t552 VIN.t127 sky130_fd_pr__pfet_01v8 ad=0.1421 pd=1.56 as=0.1421 ps=1.56 w=0.49 l=0.2
X528 VIN.t1165 VIN.t1164 OUT.t551 VIN.t233 sky130_fd_pr__pfet_01v8 ad=0.1421 pd=1.56 as=0.1421 ps=1.56 w=0.49 l=0.2
X529 OUT.t550 VIN.t1162 VIN.t1163 VIN.t72 sky130_fd_pr__pfet_01v8 ad=0.1421 pd=1.56 as=0.1421 ps=1.56 w=0.49 l=0.2
X530 VIN.t1161 VIN.t1160 OUT.t549 VIN.t49 sky130_fd_pr__pfet_01v8 ad=0.1421 pd=1.56 as=0.1421 ps=1.56 w=0.49 l=0.2
X531 a_10952_2090# a_11152_310# VSS.t56 sky130_fd_pr__res_xhigh_po_0p69 l=6.9
X532 VIN.t2118 bias-network_0.IBIAS2.t12 bias-network_0.IBIAS2.t13 VIN.t2112 sky130_fd_pr__pfet_01v8 ad=0.23925 pd=1.94 as=0.4785 ps=3.88 w=1.65 l=0.6
X533 VIN.t1159 VIN.t1158 OUT.t548 VIN.t116 sky130_fd_pr__pfet_01v8 ad=0.1421 pd=1.56 as=0.1421 ps=1.56 w=0.49 l=0.2
X534 VIN.t1157 VIN.t1156 OUT.t547 VIN.t190 sky130_fd_pr__pfet_01v8 ad=0.1421 pd=1.56 as=0.1421 ps=1.56 w=0.49 l=0.2
X535 VIN.t1155 VIN.t1154 OUT.t546 VIN.t111 sky130_fd_pr__pfet_01v8 ad=0.1421 pd=1.56 as=0.1421 ps=1.56 w=0.49 l=0.2
X536 VIN.t1153 VIN.t1152 OUT.t545 VIN.t395 sky130_fd_pr__pfet_01v8 ad=0.1421 pd=1.56 as=0.1421 ps=1.56 w=0.49 l=0.2
X537 VIN.t1151 VIN.t1150 OUT.t544 VIN.t40 sky130_fd_pr__pfet_01v8 ad=0.1421 pd=1.56 as=0.1421 ps=1.56 w=0.49 l=0.2
X538 OUT.t543 VIN.t1148 VIN.t1149 VIN.t339 sky130_fd_pr__pfet_01v8 ad=0.1421 pd=1.56 as=0.1421 ps=1.56 w=0.49 l=0.2
X539 OUT.t542 VIN.t1146 VIN.t1147 VIN.t426 sky130_fd_pr__pfet_01v8 ad=0.1421 pd=1.56 as=0.1421 ps=1.56 w=0.49 l=0.2
X540 OUT.t541 VIN.t1144 VIN.t1145 VIN.t31 sky130_fd_pr__pfet_01v8 ad=0.1421 pd=1.56 as=0.1421 ps=1.56 w=0.49 l=0.2
X541 VIN.t1143 VIN.t1142 OUT.t540 VIN.t46 sky130_fd_pr__pfet_01v8 ad=0.1421 pd=1.56 as=0.1421 ps=1.56 w=0.49 l=0.2
X542 OUT.t539 VIN.t1140 VIN.t1141 VIN.t185 sky130_fd_pr__pfet_01v8 ad=0.1421 pd=1.56 as=0.1421 ps=1.56 w=0.49 l=0.2
X543 OUT.t538 VIN.t1138 VIN.t1139 VIN.t16 sky130_fd_pr__pfet_01v8 ad=0.1421 pd=1.56 as=0.1421 ps=1.56 w=0.49 l=0.2
X544 OUT.t537 VIN.t1136 VIN.t1137 VIN.t13 sky130_fd_pr__pfet_01v8 ad=0.1421 pd=1.56 as=0.1421 ps=1.56 w=0.49 l=0.2
X545 VIN.t1135 VIN.t1134 OUT.t536 VIN.t46 sky130_fd_pr__pfet_01v8 ad=0.1421 pd=1.56 as=0.1421 ps=1.56 w=0.49 l=0.2
X546 VIN.t1133 VIN.t1132 OUT.t535 VIN.t111 sky130_fd_pr__pfet_01v8 ad=0.1421 pd=1.56 as=0.1421 ps=1.56 w=0.49 l=0.2
X547 VIN.t1131 VIN.t1130 OUT.t534 VIN.t37 sky130_fd_pr__pfet_01v8 ad=0.1421 pd=1.56 as=0.1421 ps=1.56 w=0.49 l=0.2
X548 OUT.t533 VIN.t1128 VIN.t1129 VIN.t43 sky130_fd_pr__pfet_01v8 ad=0.1421 pd=1.56 as=0.1421 ps=1.56 w=0.49 l=0.2
X549 VIN.t1127 VIN.t1126 OUT.t532 VIN.t211 sky130_fd_pr__pfet_01v8 ad=0.1421 pd=1.56 as=0.1421 ps=1.56 w=0.49 l=0.2
X550 OUT.t531 VIN.t1124 VIN.t1125 VIN.t19 sky130_fd_pr__pfet_01v8 ad=0.1421 pd=1.56 as=0.1421 ps=1.56 w=0.49 l=0.2
X551 OUT.t530 VIN.t1122 VIN.t1123 VIN.t22 sky130_fd_pr__pfet_01v8 ad=0.1421 pd=1.56 as=0.1421 ps=1.56 w=0.49 l=0.2
X552 OUT.t529 VIN.t1120 VIN.t1121 VIN.t34 sky130_fd_pr__pfet_01v8 ad=0.1421 pd=1.56 as=0.1421 ps=1.56 w=0.49 l=0.2
X553 VIN.t1119 VIN.t1118 OUT.t528 VIN.t228 sky130_fd_pr__pfet_01v8 ad=0.1421 pd=1.56 as=0.1421 ps=1.56 w=0.49 l=0.2
X554 VIN.t1117 VIN.t1116 OUT.t527 VIN.t40 sky130_fd_pr__pfet_01v8 ad=0.1421 pd=1.56 as=0.1421 ps=1.56 w=0.49 l=0.2
X555 OUT.t526 VIN.t1114 VIN.t1115 VIN.t155 sky130_fd_pr__pfet_01v8 ad=0.1421 pd=1.56 as=0.1421 ps=1.56 w=0.49 l=0.2
X556 VIN.t1113 VIN.t1112 OUT.t525 VIN.t46 sky130_fd_pr__pfet_01v8 ad=0.1421 pd=1.56 as=0.1421 ps=1.56 w=0.49 l=0.2
X557 OUT.t524 VIN.t1110 VIN.t1111 VIN.t43 sky130_fd_pr__pfet_01v8 ad=0.1421 pd=1.56 as=0.1421 ps=1.56 w=0.49 l=0.2
X558 VIN.t1109 VIN.t1108 OUT.t523 VIN.t37 sky130_fd_pr__pfet_01v8 ad=0.1421 pd=1.56 as=0.1421 ps=1.56 w=0.49 l=0.2
X559 VIN.t1107 VIN.t1106 OUT.t522 VIN.t360 sky130_fd_pr__pfet_01v8 ad=0.1421 pd=1.56 as=0.1421 ps=1.56 w=0.49 l=0.2
X560 OUT.t521 VIN.t1104 VIN.t1105 VIN.t1 sky130_fd_pr__pfet_01v8 ad=0.1421 pd=1.56 as=0.1421 ps=1.56 w=0.49 l=0.2
X561 VIN.t1103 VIN.t1102 OUT.t520 VIN.t28 sky130_fd_pr__pfet_01v8 ad=0.1421 pd=1.56 as=0.1421 ps=1.56 w=0.49 l=0.2
X562 OUT.t519 VIN.t1100 VIN.t1101 VIN.t141 sky130_fd_pr__pfet_01v8 ad=0.1421 pd=1.56 as=0.1421 ps=1.56 w=0.49 l=0.2
X563 OUT.t518 VIN.t1098 VIN.t1099 VIN.t167 sky130_fd_pr__pfet_01v8 ad=0.1421 pd=1.56 as=0.1421 ps=1.56 w=0.49 l=0.2
X564 VIN.t1097 VIN.t1096 OUT.t517 VIN.t124 sky130_fd_pr__pfet_01v8 ad=0.1421 pd=1.56 as=0.1421 ps=1.56 w=0.49 l=0.2
X565 VIN.t1095 VIN.t1094 OUT.t516 VIN.t116 sky130_fd_pr__pfet_01v8 ad=0.1421 pd=1.56 as=0.1421 ps=1.56 w=0.49 l=0.2
X566 OUT.t515 VIN.t1092 VIN.t1093 VIN.t167 sky130_fd_pr__pfet_01v8 ad=0.1421 pd=1.56 as=0.1421 ps=1.56 w=0.49 l=0.2
X567 VIN.t1091 VIN.t1090 OUT.t514 VIN.t240 sky130_fd_pr__pfet_01v8 ad=0.1421 pd=1.56 as=0.1421 ps=1.56 w=0.49 l=0.2
X568 OUT.t513 VIN.t1088 VIN.t1089 VIN.t7 sky130_fd_pr__pfet_01v8 ad=0.1421 pd=1.56 as=0.1421 ps=1.56 w=0.49 l=0.2
X569 VIN.t1087 VIN.t1086 OUT.t512 VIN.t313 sky130_fd_pr__pfet_01v8 ad=0.1421 pd=1.56 as=0.1421 ps=1.56 w=0.49 l=0.2
X570 OUT.t511 VIN.t1084 VIN.t1085 VIN.t52 sky130_fd_pr__pfet_01v8 ad=0.1421 pd=1.56 as=0.1421 ps=1.56 w=0.49 l=0.2
X571 OUT.t510 VIN.t1082 VIN.t1083 VIN.t31 sky130_fd_pr__pfet_01v8 ad=0.1421 pd=1.56 as=0.1421 ps=1.56 w=0.49 l=0.2
X572 OUT.t509 VIN.t1080 VIN.t1081 VIN.t306 sky130_fd_pr__pfet_01v8 ad=0.1421 pd=1.56 as=0.1421 ps=1.56 w=0.49 l=0.2
X573 VIN.t1079 VIN.t1078 OUT.t508 VIN.t28 sky130_fd_pr__pfet_01v8 ad=0.1421 pd=1.56 as=0.1421 ps=1.56 w=0.49 l=0.2
X574 OUT.t507 VIN.t1076 VIN.t1077 VIN.t87 sky130_fd_pr__pfet_01v8 ad=0.1421 pd=1.56 as=0.1421 ps=1.56 w=0.49 l=0.2
X575 OUT.t506 VIN.t1074 VIN.t1075 VIN.t301 sky130_fd_pr__pfet_01v8 ad=0.1421 pd=1.56 as=0.1421 ps=1.56 w=0.49 l=0.2
X576 VIN.t1073 VIN.t1072 OUT.t505 VIN.t130 sky130_fd_pr__pfet_01v8 ad=0.1421 pd=1.56 as=0.1421 ps=1.56 w=0.49 l=0.2
X577 OUT.t504 VIN.t1070 VIN.t1071 VIN.t324 sky130_fd_pr__pfet_01v8 ad=0.1421 pd=1.56 as=0.1421 ps=1.56 w=0.49 l=0.2
X578 VIN.t1069 VIN.t1068 OUT.t503 VIN.t130 sky130_fd_pr__pfet_01v8 ad=0.1421 pd=1.56 as=0.1421 ps=1.56 w=0.49 l=0.2
X579 OUT.t502 VIN.t1066 VIN.t1067 VIN.t34 sky130_fd_pr__pfet_01v8 ad=0.1421 pd=1.56 as=0.1421 ps=1.56 w=0.49 l=0.2
X580 a_10552_2090# a_10352_310# VSS.t57 sky130_fd_pr__res_xhigh_po_0p69 l=6.9
X581 OUT.t1029 VIN.t2154 sky130_fd_pr__cap_mim_m3_1 l=6 w=6
X582 VIN.t1065 VIN.t1064 OUT.t501 VIN.t240 sky130_fd_pr__pfet_01v8 ad=0.1421 pd=1.56 as=0.1421 ps=1.56 w=0.49 l=0.2
X583 VIN.t1063 VIN.t1062 OUT.t500 VIN.t28 sky130_fd_pr__pfet_01v8 ad=0.1421 pd=1.56 as=0.1421 ps=1.56 w=0.49 l=0.2
X584 VIN.t1061 VIN.t1060 OUT.t499 VIN.t75 sky130_fd_pr__pfet_01v8 ad=0.1421 pd=1.56 as=0.1421 ps=1.56 w=0.49 l=0.2
X585 OUT.t498 VIN.t1058 VIN.t1059 VIN.t306 sky130_fd_pr__pfet_01v8 ad=0.1421 pd=1.56 as=0.1421 ps=1.56 w=0.49 l=0.2
X586 VIN.t1057 VIN.t1056 OUT.t497 VIN.t55 sky130_fd_pr__pfet_01v8 ad=0.1421 pd=1.56 as=0.1421 ps=1.56 w=0.49 l=0.2
X587 VIN.t1055 VIN.t1054 OUT.t496 VIN.t360 sky130_fd_pr__pfet_01v8 ad=0.1421 pd=1.56 as=0.1421 ps=1.56 w=0.49 l=0.2
X588 VIN.t1053 VIN.t1052 OUT.t495 VIN.t66 sky130_fd_pr__pfet_01v8 ad=0.1421 pd=1.56 as=0.1421 ps=1.56 w=0.49 l=0.2
X589 VIN.t1051 VIN.t1050 OUT.t494 VIN.t63 sky130_fd_pr__pfet_01v8 ad=0.1421 pd=1.56 as=0.1421 ps=1.56 w=0.49 l=0.2
X590 OUT.t493 VIN.t1048 VIN.t1049 VIN.t269 sky130_fd_pr__pfet_01v8 ad=0.1421 pd=1.56 as=0.1421 ps=1.56 w=0.49 l=0.2
X591 a_3638_4130.t1 bias-network_0.IBIAS1.t33 a_3816_4748.t5 VIN.t2146 sky130_fd_pr__pfet_01v8 ad=1.015 pd=7.29 as=1.015 ps=7.29 w=7 l=0.6
X592 VIN.t1047 VIN.t1046 OUT.t492 VIN.t92 sky130_fd_pr__pfet_01v8 ad=0.1421 pd=1.56 as=0.1421 ps=1.56 w=0.49 l=0.2
X593 OUT.t491 VIN.t1044 VIN.t1045 VIN.t58 sky130_fd_pr__pfet_01v8 ad=0.1421 pd=1.56 as=0.1421 ps=1.56 w=0.49 l=0.2
X594 VSS.t7 a_3638_4130.t8 a_3638_4130.t9 VSS.t6 sky130_fd_pr__nfet_01v8 ad=0.15225 pd=1.34 as=0.15225 ps=1.34 w=1.05 l=0.6
X595 OUT.t490 VIN.t1042 VIN.t1043 VIN.t306 sky130_fd_pr__pfet_01v8 ad=0.1421 pd=1.56 as=0.1421 ps=1.56 w=0.49 l=0.2
X596 OUT.t489 VIN.t1040 VIN.t1041 VIN.t7 sky130_fd_pr__pfet_01v8 ad=0.1421 pd=1.56 as=0.1421 ps=1.56 w=0.49 l=0.2
X597 VIN.t1039 VIN.t1038 OUT.t488 VIN.t82 sky130_fd_pr__pfet_01v8 ad=0.1421 pd=1.56 as=0.1421 ps=1.56 w=0.49 l=0.2
X598 VIN.t1037 VIN.t1036 OUT.t487 VIN.t161 sky130_fd_pr__pfet_01v8 ad=0.1421 pd=1.56 as=0.1421 ps=1.56 w=0.49 l=0.2
X599 OUT.t486 VIN.t1034 VIN.t1035 VIN.t98 sky130_fd_pr__pfet_01v8 ad=0.1421 pd=1.56 as=0.1421 ps=1.56 w=0.49 l=0.2
X600 VIN.t1033 VIN.t1032 OUT.t485 VIN.t135 sky130_fd_pr__pfet_01v8 ad=0.1421 pd=1.56 as=0.1421 ps=1.56 w=0.49 l=0.2
X601 bias-network_0.IBIAS1.t3 bias-network_0.IBIAS1.t2 VIN.t2143 VIN.t2142 sky130_fd_pr__pfet_01v8 ad=0.4785 pd=3.88 as=0.23925 ps=1.94 w=1.65 l=0.6
X602 OUT.t484 VIN.t1030 VIN.t1031 VIN.t108 sky130_fd_pr__pfet_01v8 ad=0.1421 pd=1.56 as=0.1421 ps=1.56 w=0.49 l=0.2
X603 VIN.t1029 VIN.t1028 OUT.t483 VIN.t144 sky130_fd_pr__pfet_01v8 ad=0.1421 pd=1.56 as=0.1421 ps=1.56 w=0.49 l=0.2
X604 OUT.t482 VIN.t1026 VIN.t1027 VIN.t98 sky130_fd_pr__pfet_01v8 ad=0.1421 pd=1.56 as=0.1421 ps=1.56 w=0.49 l=0.2
X605 OUT.t481 VIN.t1024 VIN.t1025 VIN.t72 sky130_fd_pr__pfet_01v8 ad=0.1421 pd=1.56 as=0.1421 ps=1.56 w=0.49 l=0.2
X606 VSS.t9 a_3638_4130.t14 VIN.t2130 VSS.t8 sky130_fd_pr__nfet_01v8 ad=0.15225 pd=1.34 as=0.15225 ps=1.34 w=1.05 l=0.6
X607 VIN.t1023 VIN.t1022 OUT.t480 VIN.t240 sky130_fd_pr__pfet_01v8 ad=0.1421 pd=1.56 as=0.1421 ps=1.56 w=0.49 l=0.2
X608 OUT.t479 VIN.t1020 VIN.t1021 VIN.t69 sky130_fd_pr__pfet_01v8 ad=0.1421 pd=1.56 as=0.1421 ps=1.56 w=0.49 l=0.2
X609 OUT.t478 VIN.t1018 VIN.t1019 VIN.t269 sky130_fd_pr__pfet_01v8 ad=0.1421 pd=1.56 as=0.1421 ps=1.56 w=0.49 l=0.2
X610 OUT.t477 VIN.t1016 VIN.t1017 VIN.t58 sky130_fd_pr__pfet_01v8 ad=0.1421 pd=1.56 as=0.1421 ps=1.56 w=0.49 l=0.2
X611 VIN.t1015 VIN.t1014 OUT.t476 VIN.t92 sky130_fd_pr__pfet_01v8 ad=0.1421 pd=1.56 as=0.1421 ps=1.56 w=0.49 l=0.2
X612 a_8532_2090# a_8352_310# VSS.t58 sky130_fd_pr__res_xhigh_po_0p69 l=6.9
X613 VIN.t1013 VIN.t1012 OUT.t475 VIN.t211 sky130_fd_pr__pfet_01v8 ad=0.1421 pd=1.56 as=0.1421 ps=1.56 w=0.49 l=0.2
X614 OUT.t474 VIN.t1010 VIN.t1011 VIN.t19 sky130_fd_pr__pfet_01v8 ad=0.1421 pd=1.56 as=0.1421 ps=1.56 w=0.49 l=0.2
X615 OUT.t473 VIN.t1008 VIN.t1009 VIN.t1 sky130_fd_pr__pfet_01v8 ad=0.1421 pd=1.56 as=0.1421 ps=1.56 w=0.49 l=0.2
X616 VIN.t1007 VIN.t1006 OUT.t472 VIN.t135 sky130_fd_pr__pfet_01v8 ad=0.1421 pd=1.56 as=0.1421 ps=1.56 w=0.49 l=0.2
X617 OUT.t471 VIN.t1004 VIN.t1005 VIN.t34 sky130_fd_pr__pfet_01v8 ad=0.1421 pd=1.56 as=0.1421 ps=1.56 w=0.49 l=0.2
X618 VIN.t1003 VIN.t1002 OUT.t470 VIN.t211 sky130_fd_pr__pfet_01v8 ad=0.1421 pd=1.56 as=0.1421 ps=1.56 w=0.49 l=0.2
X619 OUT.t469 VIN.t1000 VIN.t1001 VIN.t13 sky130_fd_pr__pfet_01v8 ad=0.1421 pd=1.56 as=0.1421 ps=1.56 w=0.49 l=0.2
X620 OUT.t468 VIN.t998 VIN.t999 VIN.t16 sky130_fd_pr__pfet_01v8 ad=0.1421 pd=1.56 as=0.1421 ps=1.56 w=0.49 l=0.2
X621 VIN.t997 VIN.t996 OUT.t467 VIN.t240 sky130_fd_pr__pfet_01v8 ad=0.1421 pd=1.56 as=0.1421 ps=1.56 w=0.49 l=0.2
X622 VIN.t995 VIN.t994 OUT.t466 VIN.t190 sky130_fd_pr__pfet_01v8 ad=0.1421 pd=1.56 as=0.1421 ps=1.56 w=0.49 l=0.2
X623 OUT.t465 VIN.t992 VIN.t993 VIN.t87 sky130_fd_pr__pfet_01v8 ad=0.1421 pd=1.56 as=0.1421 ps=1.56 w=0.49 l=0.2
X624 VIN.t991 VIN.t990 OUT.t464 VIN.t233 sky130_fd_pr__pfet_01v8 ad=0.1421 pd=1.56 as=0.1421 ps=1.56 w=0.49 l=0.2
X625 a_3300_2480# a_2900_700# VSS.t59 sky130_fd_pr__res_xhigh_po_0p69 l=6.9
X626 VIN.t989 VIN.t988 OUT.t463 VIN.t82 sky130_fd_pr__pfet_01v8 ad=0.1421 pd=1.56 as=0.1421 ps=1.56 w=0.49 l=0.2
X627 OUT.t462 VIN.t986 VIN.t987 VIN.t31 sky130_fd_pr__pfet_01v8 ad=0.1421 pd=1.56 as=0.1421 ps=1.56 w=0.49 l=0.2
X628 VIN.t985 VIN.t984 OUT.t461 VIN.t40 sky130_fd_pr__pfet_01v8 ad=0.1421 pd=1.56 as=0.1421 ps=1.56 w=0.49 l=0.2
X629 VIN.t983 VIN.t982 OUT.t460 VIN.t211 sky130_fd_pr__pfet_01v8 ad=0.1421 pd=1.56 as=0.1421 ps=1.56 w=0.49 l=0.2
X630 OUT.t459 VIN.t980 VIN.t981 VIN.t4 sky130_fd_pr__pfet_01v8 ad=0.1421 pd=1.56 as=0.1421 ps=1.56 w=0.49 l=0.2
X631 a_816_4748.t10 bias-network_0.IBIAS2.t18 VIN.t2125 VIN.t2124 sky130_fd_pr__pfet_01v8 ad=0.23925 pd=1.94 as=0.23925 ps=1.94 w=1.65 l=0.6
X632 VIN.t979 VIN.t978 OUT.t458 VIN.t395 sky130_fd_pr__pfet_01v8 ad=0.1421 pd=1.56 as=0.1421 ps=1.56 w=0.49 l=0.2
X633 OUT.t457 VIN.t976 VIN.t977 VIN.t19 sky130_fd_pr__pfet_01v8 ad=0.1421 pd=1.56 as=0.1421 ps=1.56 w=0.49 l=0.2
X634 VIN.t975 VIN.t974 OUT.t456 VIN.t75 sky130_fd_pr__pfet_01v8 ad=0.1421 pd=1.56 as=0.1421 ps=1.56 w=0.49 l=0.2
X635 VIN.t973 VIN.t972 OUT.t455 VIN.t46 sky130_fd_pr__pfet_01v8 ad=0.1421 pd=1.56 as=0.1421 ps=1.56 w=0.49 l=0.2
X636 OUT.t454 VIN.t970 VIN.t971 VIN.t185 sky130_fd_pr__pfet_01v8 ad=0.1421 pd=1.56 as=0.1421 ps=1.56 w=0.49 l=0.2
X637 OUT.t453 VIN.t968 VIN.t969 VIN.t158 sky130_fd_pr__pfet_01v8 ad=0.1421 pd=1.56 as=0.1421 ps=1.56 w=0.49 l=0.2
X638 VIN.t967 VIN.t966 OUT.t452 VIN.t211 sky130_fd_pr__pfet_01v8 ad=0.1421 pd=1.56 as=0.1421 ps=1.56 w=0.49 l=0.2
X639 OUT.t451 VIN.t964 VIN.t965 VIN.t164 sky130_fd_pr__pfet_01v8 ad=0.1421 pd=1.56 as=0.1421 ps=1.56 w=0.49 l=0.2
X640 OUT.t450 VIN.t962 VIN.t963 VIN.t138 sky130_fd_pr__pfet_01v8 ad=0.1421 pd=1.56 as=0.1421 ps=1.56 w=0.49 l=0.2
X641 OUT.t449 VIN.t960 VIN.t961 VIN.t4 sky130_fd_pr__pfet_01v8 ad=0.1421 pd=1.56 as=0.1421 ps=1.56 w=0.49 l=0.2
X642 OUT.t448 VIN.t958 VIN.t959 VIN.t31 sky130_fd_pr__pfet_01v8 ad=0.1421 pd=1.56 as=0.1421 ps=1.56 w=0.49 l=0.2
X643 OUT.t447 VIN.t956 VIN.t957 VIN.t87 sky130_fd_pr__pfet_01v8 ad=0.1421 pd=1.56 as=0.1421 ps=1.56 w=0.49 l=0.2
X644 VIN.t955 VIN.t954 OUT.t446 VIN.t111 sky130_fd_pr__pfet_01v8 ad=0.1421 pd=1.56 as=0.1421 ps=1.56 w=0.49 l=0.2
X645 VIN.t953 VIN.t952 OUT.t445 VIN.t178 sky130_fd_pr__pfet_01v8 ad=0.1421 pd=1.56 as=0.1421 ps=1.56 w=0.49 l=0.2
X646 VIN.t951 VIN.t950 OUT.t444 VIN.t25 sky130_fd_pr__pfet_01v8 ad=0.1421 pd=1.56 as=0.1421 ps=1.56 w=0.49 l=0.2
X647 VIN.t2131 a_3638_4130.t15 VSS.t5 VSS.t4 sky130_fd_pr__nfet_01v8 ad=0.15225 pd=1.34 as=0.15225 ps=1.34 w=1.05 l=0.6
X648 OUT.t443 VIN.t948 VIN.t949 VIN.t185 sky130_fd_pr__pfet_01v8 ad=0.1421 pd=1.56 as=0.1421 ps=1.56 w=0.49 l=0.2
X649 OUT.t442 VIN.t946 VIN.t947 VIN.t155 sky130_fd_pr__pfet_01v8 ad=0.1421 pd=1.56 as=0.1421 ps=1.56 w=0.49 l=0.2
X650 VIN.t945 VIN.t944 OUT.t441 VIN.t66 sky130_fd_pr__pfet_01v8 ad=0.1421 pd=1.56 as=0.1421 ps=1.56 w=0.49 l=0.2
X651 VIN.t943 VIN.t942 OUT.t440 VIN.t10 sky130_fd_pr__pfet_01v8 ad=0.1421 pd=1.56 as=0.1421 ps=1.56 w=0.49 l=0.2
X652 bias-network_0.IBIAS1.t22 bias-network_0.VREF.t24 a_816_4748.t1 VIN.t2120 sky130_fd_pr__pfet_01v8 ad=1.015 pd=7.29 as=1.015 ps=7.29 w=7 l=0.6
X653 VIN.t941 VIN.t940 OUT.t439 VIN.t63 sky130_fd_pr__pfet_01v8 ad=0.1421 pd=1.56 as=0.1421 ps=1.56 w=0.49 l=0.2
X654 OUT.t438 VIN.t938 VIN.t939 VIN.t1 sky130_fd_pr__pfet_01v8 ad=0.1421 pd=1.56 as=0.1421 ps=1.56 w=0.49 l=0.2
X655 OUT.t437 VIN.t936 VIN.t937 VIN.t87 sky130_fd_pr__pfet_01v8 ad=0.1421 pd=1.56 as=0.1421 ps=1.56 w=0.49 l=0.2
X656 a_3300_2480# OUT.t0 VSS.t60 sky130_fd_pr__res_xhigh_po_0p69 l=6.9
X657 OUT.t436 VIN.t934 VIN.t935 VIN.t141 sky130_fd_pr__pfet_01v8 ad=0.1421 pd=1.56 as=0.1421 ps=1.56 w=0.49 l=0.2
X658 VIN.t933 VIN.t932 OUT.t435 VIN.t116 sky130_fd_pr__pfet_01v8 ad=0.1421 pd=1.56 as=0.1421 ps=1.56 w=0.49 l=0.2
X659 VIN.t931 VIN.t930 OUT.t434 VIN.t101 sky130_fd_pr__pfet_01v8 ad=0.1421 pd=1.56 as=0.1421 ps=1.56 w=0.49 l=0.2
X660 OUT.t433 VIN.t928 VIN.t929 VIN.t426 sky130_fd_pr__pfet_01v8 ad=0.1421 pd=1.56 as=0.1421 ps=1.56 w=0.49 l=0.2
X661 VIN.t927 VIN.t926 OUT.t432 VIN.t124 sky130_fd_pr__pfet_01v8 ad=0.1421 pd=1.56 as=0.1421 ps=1.56 w=0.49 l=0.2
X662 OUT.t431 VIN.t924 VIN.t925 VIN.t167 sky130_fd_pr__pfet_01v8 ad=0.1421 pd=1.56 as=0.1421 ps=1.56 w=0.49 l=0.2
X663 OUT.t430 VIN.t922 VIN.t923 VIN.t155 sky130_fd_pr__pfet_01v8 ad=0.1421 pd=1.56 as=0.1421 ps=1.56 w=0.49 l=0.2
X664 OUT.t429 VIN.t920 VIN.t921 VIN.t167 sky130_fd_pr__pfet_01v8 ad=0.1421 pd=1.56 as=0.1421 ps=1.56 w=0.49 l=0.2
X665 VIN.t919 VIN.t918 OUT.t428 VIN.t161 sky130_fd_pr__pfet_01v8 ad=0.1421 pd=1.56 as=0.1421 ps=1.56 w=0.49 l=0.2
X666 OUT.t427 VIN.t916 VIN.t917 VIN.t164 sky130_fd_pr__pfet_01v8 ad=0.1421 pd=1.56 as=0.1421 ps=1.56 w=0.49 l=0.2
X667 VSS.t106 a_638_4130.t8 a_638_4130.t9 VSS.t105 sky130_fd_pr__nfet_01v8 ad=0.15225 pd=1.34 as=0.3045 ps=2.68 w=1.05 l=0.6
X668 OUT.t426 VIN.t914 VIN.t915 VIN.t108 sky130_fd_pr__pfet_01v8 ad=0.1421 pd=1.56 as=0.1421 ps=1.56 w=0.49 l=0.2
X669 OUT.t425 VIN.t912 VIN.t913 VIN.t52 sky130_fd_pr__pfet_01v8 ad=0.1421 pd=1.56 as=0.1421 ps=1.56 w=0.49 l=0.2
X670 VIN.t911 VIN.t910 OUT.t424 VIN.t313 sky130_fd_pr__pfet_01v8 ad=0.1421 pd=1.56 as=0.1421 ps=1.56 w=0.49 l=0.2
X671 OUT.t423 VIN.t908 VIN.t909 VIN.t108 sky130_fd_pr__pfet_01v8 ad=0.1421 pd=1.56 as=0.1421 ps=1.56 w=0.49 l=0.2
X672 a_9732_2090# a_9952_310# VSS.t61 sky130_fd_pr__res_xhigh_po_0p69 l=6.9
X673 OUT.t422 VIN.t906 VIN.t907 VIN.t301 sky130_fd_pr__pfet_01v8 ad=0.1421 pd=1.56 as=0.1421 ps=1.56 w=0.49 l=0.2
X674 VIN.t905 VIN.t904 OUT.t421 VIN.t144 sky130_fd_pr__pfet_01v8 ad=0.1421 pd=1.56 as=0.1421 ps=1.56 w=0.49 l=0.2
X675 OUT.t420 VIN.t902 VIN.t903 VIN.t138 sky130_fd_pr__pfet_01v8 ad=0.1421 pd=1.56 as=0.1421 ps=1.56 w=0.49 l=0.2
X676 VIN.t901 VIN.t900 OUT.t419 VIN.t130 sky130_fd_pr__pfet_01v8 ad=0.1421 pd=1.56 as=0.1421 ps=1.56 w=0.49 l=0.2
X677 VSS.t35 bias-network_0.VREF.t25 bias-network_0.IBIAS1.t23 VSS.t21 sky130_fd_pr__nfet_01v8 ad=0.10875 pd=1.04 as=0.2175 ps=2.08 w=0.75 l=2
X678 VIN.t899 VIN.t898 OUT.t418 VIN.t116 sky130_fd_pr__pfet_01v8 ad=0.1421 pd=1.56 as=0.1421 ps=1.56 w=0.49 l=0.2
X679 VIN.t897 VIN.t896 OUT.t417 VIN.t130 sky130_fd_pr__pfet_01v8 ad=0.1421 pd=1.56 as=0.1421 ps=1.56 w=0.49 l=0.2
X680 OUT.t416 VIN.t894 VIN.t895 VIN.t34 sky130_fd_pr__pfet_01v8 ad=0.1421 pd=1.56 as=0.1421 ps=1.56 w=0.49 l=0.2
X681 VIN.t893 VIN.t892 OUT.t415 VIN.t124 sky130_fd_pr__pfet_01v8 ad=0.1421 pd=1.56 as=0.1421 ps=1.56 w=0.49 l=0.2
X682 VIN.t891 VIN.t890 OUT.t414 VIN.t124 sky130_fd_pr__pfet_01v8 ad=0.1421 pd=1.56 as=0.1421 ps=1.56 w=0.49 l=0.2
X683 OUT.t413 VIN.t888 VIN.t889 VIN.t72 sky130_fd_pr__pfet_01v8 ad=0.1421 pd=1.56 as=0.1421 ps=1.56 w=0.49 l=0.2
X684 VIN.t887 VIN.t886 OUT.t412 VIN.t116 sky130_fd_pr__pfet_01v8 ad=0.1421 pd=1.56 as=0.1421 ps=1.56 w=0.49 l=0.2
X685 VIN.t885 VIN.t884 OUT.t411 VIN.t75 sky130_fd_pr__pfet_01v8 ad=0.1421 pd=1.56 as=0.1421 ps=1.56 w=0.49 l=0.2
X686 VIN.t883 VIN.t882 OUT.t410 VIN.t63 sky130_fd_pr__pfet_01v8 ad=0.1421 pd=1.56 as=0.1421 ps=1.56 w=0.49 l=0.2
X687 OUT.t409 VIN.t880 VIN.t881 VIN.t108 sky130_fd_pr__pfet_01v8 ad=0.1421 pd=1.56 as=0.1421 ps=1.56 w=0.49 l=0.2
X688 VIN.t879 VIN.t878 OUT.t408 VIN.t111 sky130_fd_pr__pfet_01v8 ad=0.1421 pd=1.56 as=0.1421 ps=1.56 w=0.49 l=0.2
X689 VSS.t34 bias-network_0.VREF.t26 bias-network_0.IBIAS1.t24 VSS.t21 sky130_fd_pr__nfet_01v8 ad=0.10875 pd=1.04 as=0.2175 ps=2.08 w=0.75 l=2
X690 VIN.t877 VIN.t876 OUT.t407 VIN.t55 sky130_fd_pr__pfet_01v8 ad=0.1421 pd=1.56 as=0.1421 ps=1.56 w=0.49 l=0.2
X691 OUT.t406 VIN.t874 VIN.t875 VIN.t426 sky130_fd_pr__pfet_01v8 ad=0.1421 pd=1.56 as=0.1421 ps=1.56 w=0.49 l=0.2
X692 VIN.t873 VIN.t872 OUT.t405 VIN.t66 sky130_fd_pr__pfet_01v8 ad=0.1421 pd=1.56 as=0.1421 ps=1.56 w=0.49 l=0.2
X693 OUT.t404 VIN.t870 VIN.t871 VIN.t69 sky130_fd_pr__pfet_01v8 ad=0.1421 pd=1.56 as=0.1421 ps=1.56 w=0.49 l=0.2
X694 OUT.t403 VIN.t868 VIN.t869 VIN.t339 sky130_fd_pr__pfet_01v8 ad=0.1421 pd=1.56 as=0.1421 ps=1.56 w=0.49 l=0.2
X695 OUT.t402 VIN.t866 VIN.t867 VIN.t58 sky130_fd_pr__pfet_01v8 ad=0.1421 pd=1.56 as=0.1421 ps=1.56 w=0.49 l=0.2
X696 VIN.t865 VIN.t864 OUT.t401 VIN.t92 sky130_fd_pr__pfet_01v8 ad=0.1421 pd=1.56 as=0.1421 ps=1.56 w=0.49 l=0.2
X697 OUT.t400 VIN.t862 VIN.t863 VIN.t16 sky130_fd_pr__pfet_01v8 ad=0.1421 pd=1.56 as=0.1421 ps=1.56 w=0.49 l=0.2
X698 OUT.t399 VIN.t860 VIN.t861 VIN.t87 sky130_fd_pr__pfet_01v8 ad=0.1421 pd=1.56 as=0.1421 ps=1.56 w=0.49 l=0.2
X699 VIN.t859 VIN.t858 OUT.t398 VIN.t82 sky130_fd_pr__pfet_01v8 ad=0.1421 pd=1.56 as=0.1421 ps=1.56 w=0.49 l=0.2
X700 OUT.t397 VIN.t856 VIN.t857 VIN.t7 sky130_fd_pr__pfet_01v8 ad=0.1421 pd=1.56 as=0.1421 ps=1.56 w=0.49 l=0.2
X701 VIN.t855 VIN.t854 OUT.t396 VIN.t49 sky130_fd_pr__pfet_01v8 ad=0.1421 pd=1.56 as=0.1421 ps=1.56 w=0.49 l=0.2
X702 OUT.t395 VIN.t852 VIN.t853 VIN.t72 sky130_fd_pr__pfet_01v8 ad=0.1421 pd=1.56 as=0.1421 ps=1.56 w=0.49 l=0.2
X703 OUT.t394 VIN.t850 VIN.t851 VIN.t269 sky130_fd_pr__pfet_01v8 ad=0.1421 pd=1.56 as=0.1421 ps=1.56 w=0.49 l=0.2
X704 VIN.t849 VIN.t848 OUT.t393 VIN.t95 sky130_fd_pr__pfet_01v8 ad=0.1421 pd=1.56 as=0.1421 ps=1.56 w=0.49 l=0.2
X705 VIN.t847 VIN.t846 OUT.t392 VIN.t75 sky130_fd_pr__pfet_01v8 ad=0.1421 pd=1.56 as=0.1421 ps=1.56 w=0.49 l=0.2
X706 VIN.t845 VIN.t844 OUT.t391 VIN.t144 sky130_fd_pr__pfet_01v8 ad=0.1421 pd=1.56 as=0.1421 ps=1.56 w=0.49 l=0.2
X707 VIN.t843 VIN.t842 OUT.t390 VIN.t233 sky130_fd_pr__pfet_01v8 ad=0.1421 pd=1.56 as=0.1421 ps=1.56 w=0.49 l=0.2
X708 OUT.t389 VIN.t840 VIN.t841 VIN.t58 sky130_fd_pr__pfet_01v8 ad=0.1421 pd=1.56 as=0.1421 ps=1.56 w=0.49 l=0.2
X709 OUT.t388 VIN.t838 VIN.t839 VIN.t69 sky130_fd_pr__pfet_01v8 ad=0.1421 pd=1.56 as=0.1421 ps=1.56 w=0.49 l=0.2
X710 OUT.t387 VIN.t836 VIN.t837 VIN.t58 sky130_fd_pr__pfet_01v8 ad=0.1421 pd=1.56 as=0.1421 ps=1.56 w=0.49 l=0.2
X711 VIN.t835 VIN.t834 OUT.t386 VIN.t228 sky130_fd_pr__pfet_01v8 ad=0.1421 pd=1.56 as=0.1421 ps=1.56 w=0.49 l=0.2
X712 VIN.t833 VIN.t832 OUT.t385 VIN.t40 sky130_fd_pr__pfet_01v8 ad=0.1421 pd=1.56 as=0.1421 ps=1.56 w=0.49 l=0.2
X713 OUT.t384 VIN.t830 VIN.t831 VIN.t1 sky130_fd_pr__pfet_01v8 ad=0.1421 pd=1.56 as=0.1421 ps=1.56 w=0.49 l=0.2
X714 a_8152_2090# a_8352_310# VSS.t62 sky130_fd_pr__res_xhigh_po_0p69 l=6.9
X715 OUT.t383 VIN.t828 VIN.t829 VIN.t34 sky130_fd_pr__pfet_01v8 ad=0.1421 pd=1.56 as=0.1421 ps=1.56 w=0.49 l=0.2
X716 VIN.t827 VIN.t826 OUT.t382 VIN.t28 sky130_fd_pr__pfet_01v8 ad=0.1421 pd=1.56 as=0.1421 ps=1.56 w=0.49 l=0.2
X717 VIN.t825 VIN.t824 OUT.t381 VIN.t360 sky130_fd_pr__pfet_01v8 ad=0.1421 pd=1.56 as=0.1421 ps=1.56 w=0.49 l=0.2
X718 OUT.t380 VIN.t822 VIN.t823 VIN.t13 sky130_fd_pr__pfet_01v8 ad=0.1421 pd=1.56 as=0.1421 ps=1.56 w=0.49 l=0.2
X719 OUT.t379 VIN.t820 VIN.t821 VIN.t7 sky130_fd_pr__pfet_01v8 ad=0.1421 pd=1.56 as=0.1421 ps=1.56 w=0.49 l=0.2
X720 OUT.t378 VIN.t818 VIN.t819 VIN.t22 sky130_fd_pr__pfet_01v8 ad=0.1421 pd=1.56 as=0.1421 ps=1.56 w=0.49 l=0.2
X721 OUT.t377 VIN.t816 VIN.t817 VIN.t16 sky130_fd_pr__pfet_01v8 ad=0.1421 pd=1.56 as=0.1421 ps=1.56 w=0.49 l=0.2
X722 VIN.t815 VIN.t814 OUT.t376 VIN.t10 sky130_fd_pr__pfet_01v8 ad=0.1421 pd=1.56 as=0.1421 ps=1.56 w=0.49 l=0.2
X723 VIN.t813 VIN.t812 OUT.t375 VIN.t82 sky130_fd_pr__pfet_01v8 ad=0.1421 pd=1.56 as=0.1421 ps=1.56 w=0.49 l=0.2
X724 VIN.t811 VIN.t810 OUT.t374 VIN.t190 sky130_fd_pr__pfet_01v8 ad=0.1421 pd=1.56 as=0.1421 ps=1.56 w=0.49 l=0.2
X725 OUT.t373 VIN.t808 VIN.t809 VIN.t4 sky130_fd_pr__pfet_01v8 ad=0.1421 pd=1.56 as=0.1421 ps=1.56 w=0.49 l=0.2
X726 OUT.t372 VIN.t806 VIN.t807 VIN.t141 sky130_fd_pr__pfet_01v8 ad=0.1421 pd=1.56 as=0.1421 ps=1.56 w=0.49 l=0.2
X727 OUT.t371 VIN.t804 VIN.t805 VIN.t324 sky130_fd_pr__pfet_01v8 ad=0.1421 pd=1.56 as=0.1421 ps=1.56 w=0.49 l=0.2
X728 VIN.t803 VIN.t802 OUT.t370 VIN.t161 sky130_fd_pr__pfet_01v8 ad=0.1421 pd=1.56 as=0.1421 ps=1.56 w=0.49 l=0.2
X729 VIN.t801 VIN.t800 OUT.t369 VIN.t75 sky130_fd_pr__pfet_01v8 ad=0.1421 pd=1.56 as=0.1421 ps=1.56 w=0.49 l=0.2
X730 OUT.t368 VIN.t798 VIN.t799 VIN.t1 sky130_fd_pr__pfet_01v8 ad=0.1421 pd=1.56 as=0.1421 ps=1.56 w=0.49 l=0.2
X731 OUT.t367 VIN.t796 VIN.t797 VIN.t164 sky130_fd_pr__pfet_01v8 ad=0.1421 pd=1.56 as=0.1421 ps=1.56 w=0.49 l=0.2
X732 OUT.t366 VIN.t794 VIN.t795 VIN.t158 sky130_fd_pr__pfet_01v8 ad=0.1421 pd=1.56 as=0.1421 ps=1.56 w=0.49 l=0.2
X733 OUT.t1030 bias-network_0.IBIAS1.t9 sky130_fd_pr__cap_mim_m3_1 l=6 w=6
X734 VIN.t793 VIN.t792 OUT.t365 VIN.t46 sky130_fd_pr__pfet_01v8 ad=0.1421 pd=1.56 as=0.1421 ps=1.56 w=0.49 l=0.2
X735 OUT.t364 VIN.t790 VIN.t791 VIN.t138 sky130_fd_pr__pfet_01v8 ad=0.1421 pd=1.56 as=0.1421 ps=1.56 w=0.49 l=0.2
X736 OUT.t363 VIN.t788 VIN.t789 VIN.t278 sky130_fd_pr__pfet_01v8 ad=0.1421 pd=1.56 as=0.1421 ps=1.56 w=0.49 l=0.2
X737 a_2300_2480# a_1900_700# VSS.t63 sky130_fd_pr__res_xhigh_po_0p69 l=6.9
X738 OUT.t362 VIN.t786 VIN.t787 VIN.t31 sky130_fd_pr__pfet_01v8 ad=0.1421 pd=1.56 as=0.1421 ps=1.56 w=0.49 l=0.2
X739 OUT.t361 VIN.t784 VIN.t785 VIN.t324 sky130_fd_pr__pfet_01v8 ad=0.1421 pd=1.56 as=0.1421 ps=1.56 w=0.49 l=0.2
X740 VIN.t783 VIN.t782 OUT.t360 VIN.t178 sky130_fd_pr__pfet_01v8 ad=0.1421 pd=1.56 as=0.1421 ps=1.56 w=0.49 l=0.2
X741 a_3638_4130.t7 a_3638_4130.t6 VSS.t3 VSS.t2 sky130_fd_pr__nfet_01v8 ad=0.3045 pd=2.68 as=0.15225 ps=1.34 w=1.05 l=0.6
X742 OUT.t359 VIN.t780 VIN.t781 VIN.t4 sky130_fd_pr__pfet_01v8 ad=0.1421 pd=1.56 as=0.1421 ps=1.56 w=0.49 l=0.2
X743 VIN.t779 VIN.t778 OUT.t358 VIN.t360 sky130_fd_pr__pfet_01v8 ad=0.1421 pd=1.56 as=0.1421 ps=1.56 w=0.49 l=0.2
X744 OUT.t357 VIN.t776 VIN.t777 VIN.t158 sky130_fd_pr__pfet_01v8 ad=0.1421 pd=1.56 as=0.1421 ps=1.56 w=0.49 l=0.2
X745 a_n100_2480# VSS.t65 VSS.t64 sky130_fd_pr__res_xhigh_po_0p69 l=6.9
X746 OUT.t356 VIN.t774 VIN.t775 VIN.t301 sky130_fd_pr__pfet_01v8 ad=0.1421 pd=1.56 as=0.1421 ps=1.56 w=0.49 l=0.2
X747 OUT.t355 VIN.t772 VIN.t773 VIN.t164 sky130_fd_pr__pfet_01v8 ad=0.1421 pd=1.56 as=0.1421 ps=1.56 w=0.49 l=0.2
X748 OUT.t354 VIN.t770 VIN.t771 VIN.t306 sky130_fd_pr__pfet_01v8 ad=0.1421 pd=1.56 as=0.1421 ps=1.56 w=0.49 l=0.2
X749 VIN.t769 VIN.t768 OUT.t353 VIN.t66 sky130_fd_pr__pfet_01v8 ad=0.1421 pd=1.56 as=0.1421 ps=1.56 w=0.49 l=0.2
X750 VIN.t767 VIN.t766 OUT.t352 VIN.t25 sky130_fd_pr__pfet_01v8 ad=0.1421 pd=1.56 as=0.1421 ps=1.56 w=0.49 l=0.2
X751 OUT.t351 VIN.t764 VIN.t765 VIN.t72 sky130_fd_pr__pfet_01v8 ad=0.1421 pd=1.56 as=0.1421 ps=1.56 w=0.49 l=0.2
X752 VIN.t763 VIN.t762 OUT.t350 VIN.t63 sky130_fd_pr__pfet_01v8 ad=0.1421 pd=1.56 as=0.1421 ps=1.56 w=0.49 l=0.2
X753 OUT.t349 VIN.t760 VIN.t761 VIN.t98 sky130_fd_pr__pfet_01v8 ad=0.1421 pd=1.56 as=0.1421 ps=1.56 w=0.49 l=0.2
X754 OUT.t348 VIN.t758 VIN.t759 VIN.t155 sky130_fd_pr__pfet_01v8 ad=0.1421 pd=1.56 as=0.1421 ps=1.56 w=0.49 l=0.2
X755 a_816_4748.t0 bias-network_0.VREF.t27 bias-network_0.IBIAS1.t25 VIN.t2122 sky130_fd_pr__pfet_01v8 ad=1.015 pd=7.29 as=1.015 ps=7.29 w=7 l=0.6
X756 OUT.t347 VIN.t756 VIN.t757 VIN.t185 sky130_fd_pr__pfet_01v8 ad=0.1421 pd=1.56 as=0.1421 ps=1.56 w=0.49 l=0.2
X757 VIN.t755 VIN.t754 OUT.t346 VIN.t178 sky130_fd_pr__pfet_01v8 ad=0.1421 pd=1.56 as=0.1421 ps=1.56 w=0.49 l=0.2
X758 VIN.t753 VIN.t752 OUT.t345 VIN.t55 sky130_fd_pr__pfet_01v8 ad=0.1421 pd=1.56 as=0.1421 ps=1.56 w=0.49 l=0.2
X759 VIN.t751 VIN.t750 OUT.t344 VIN.t178 sky130_fd_pr__pfet_01v8 ad=0.1421 pd=1.56 as=0.1421 ps=1.56 w=0.49 l=0.2
X760 OUT.t343 VIN.t748 VIN.t749 VIN.t426 sky130_fd_pr__pfet_01v8 ad=0.1421 pd=1.56 as=0.1421 ps=1.56 w=0.49 l=0.2
X761 VIN.t747 VIN.t746 OUT.t342 VIN.t101 sky130_fd_pr__pfet_01v8 ad=0.1421 pd=1.56 as=0.1421 ps=1.56 w=0.49 l=0.2
X762 OUT.t341 VIN.t744 VIN.t745 VIN.t339 sky130_fd_pr__pfet_01v8 ad=0.1421 pd=1.56 as=0.1421 ps=1.56 w=0.49 l=0.2
X763 OUT.t340 VIN.t742 VIN.t743 VIN.t141 sky130_fd_pr__pfet_01v8 ad=0.1421 pd=1.56 as=0.1421 ps=1.56 w=0.49 l=0.2
X764 bias-network_0.IBIAS1.t26 bias-network_0.VREF.t28 VSS.t33 VSS.t17 sky130_fd_pr__nfet_01v8 ad=0.2175 pd=2.08 as=0.10875 ps=1.04 w=0.75 l=2
X765 OUT.t339 VIN.t740 VIN.t741 VIN.t155 sky130_fd_pr__pfet_01v8 ad=0.1421 pd=1.56 as=0.1421 ps=1.56 w=0.49 l=0.2
X766 OUT.t338 VIN.t738 VIN.t739 VIN.t164 sky130_fd_pr__pfet_01v8 ad=0.1421 pd=1.56 as=0.1421 ps=1.56 w=0.49 l=0.2
X767 VIN.t737 VIN.t736 OUT.t337 VIN.t161 sky130_fd_pr__pfet_01v8 ad=0.1421 pd=1.56 as=0.1421 ps=1.56 w=0.49 l=0.2
X768 OUT.t336 VIN.t734 VIN.t735 VIN.t108 sky130_fd_pr__pfet_01v8 ad=0.1421 pd=1.56 as=0.1421 ps=1.56 w=0.49 l=0.2
X769 VIN.t733 VIN.t732 OUT.t335 VIN.t92 sky130_fd_pr__pfet_01v8 ad=0.1421 pd=1.56 as=0.1421 ps=1.56 w=0.49 l=0.2
X770 bias-network_0.IBIAS1.t14 a_638_4130.t14 VSS.t114 VSS.t113 sky130_fd_pr__nfet_01v8 ad=0.15225 pd=1.34 as=0.15225 ps=1.34 w=1.05 l=0.6
X771 a_2300_2480# a_2700_700# VSS.t66 sky130_fd_pr__res_xhigh_po_0p69 l=6.9
X772 bias-network_0.IBIAS1.t27 bias-network_0.VREF.t29 VSS.t32 VSS.t17 sky130_fd_pr__nfet_01v8 ad=0.2175 pd=2.08 as=0.10875 ps=1.04 w=0.75 l=2
X773 a_11752_2090# a_11552_310# VSS.t67 sky130_fd_pr__res_xhigh_po_0p69 l=6.9
X774 VIN.t731 VIN.t730 OUT.t334 VIN.t395 sky130_fd_pr__pfet_01v8 ad=0.1421 pd=1.56 as=0.1421 ps=1.56 w=0.49 l=0.2
X775 VIN.t729 VIN.t728 OUT.t333 VIN.t144 sky130_fd_pr__pfet_01v8 ad=0.1421 pd=1.56 as=0.1421 ps=1.56 w=0.49 l=0.2
X776 VSS.t31 bias-network_0.VREF.t30 bias-network_0.IBIAS2.t7 VSS.t29 sky130_fd_pr__nfet_01v8 ad=0.10875 pd=1.04 as=0.10875 ps=1.04 w=0.75 l=2
X777 VIN.t727 VIN.t726 OUT.t332 VIN.t55 sky130_fd_pr__pfet_01v8 ad=0.1421 pd=1.56 as=0.1421 ps=1.56 w=0.49 l=0.2
X778 a_100_2480# divider-feedback_0.VFB.t0 VSS.t68 sky130_fd_pr__res_xhigh_po_0p69 l=6.9
X779 OUT.t331 VIN.t724 VIN.t725 VIN.t69 sky130_fd_pr__pfet_01v8 ad=0.1421 pd=1.56 as=0.1421 ps=1.56 w=0.49 l=0.2
X780 VIN.t723 VIN.t722 OUT.t330 VIN.t101 sky130_fd_pr__pfet_01v8 ad=0.1421 pd=1.56 as=0.1421 ps=1.56 w=0.49 l=0.2
X781 VIN.t2117 bias-network_0.IBIAS2.t10 bias-network_0.IBIAS2.t11 VIN.t2115 sky130_fd_pr__pfet_01v8 ad=0.23925 pd=1.94 as=0.23925 ps=1.94 w=1.65 l=0.6
X782 VIN.t721 VIN.t720 OUT.t329 VIN.t124 sky130_fd_pr__pfet_01v8 ad=0.1421 pd=1.56 as=0.1421 ps=1.56 w=0.49 l=0.2
X783 OUT.t328 VIN.t718 VIN.t719 VIN.t119 sky130_fd_pr__pfet_01v8 ad=0.1421 pd=1.56 as=0.1421 ps=1.56 w=0.49 l=0.2
X784 OUT.t327 VIN.t716 VIN.t717 VIN.t138 sky130_fd_pr__pfet_01v8 ad=0.1421 pd=1.56 as=0.1421 ps=1.56 w=0.49 l=0.2
X785 VIN.t715 VIN.t714 OUT.t326 VIN.t228 sky130_fd_pr__pfet_01v8 ad=0.1421 pd=1.56 as=0.1421 ps=1.56 w=0.49 l=0.2
X786 VIN.t713 VIN.t712 OUT.t325 VIN.t116 sky130_fd_pr__pfet_01v8 ad=0.1421 pd=1.56 as=0.1421 ps=1.56 w=0.49 l=0.2
X787 VIN.t711 VIN.t710 OUT.t324 VIN.t233 sky130_fd_pr__pfet_01v8 ad=0.1421 pd=1.56 as=0.1421 ps=1.56 w=0.49 l=0.2
X788 VIN.t709 VIN.t708 OUT.t323 VIN.t40 sky130_fd_pr__pfet_01v8 ad=0.1421 pd=1.56 as=0.1421 ps=1.56 w=0.49 l=0.2
X789 VIN.t707 VIN.t706 OUT.t322 VIN.t111 sky130_fd_pr__pfet_01v8 ad=0.1421 pd=1.56 as=0.1421 ps=1.56 w=0.49 l=0.2
X790 VSS.t30 bias-network_0.VREF.t31 bias-network_0.IBIAS2.t6 VSS.t29 sky130_fd_pr__nfet_01v8 ad=0.10875 pd=1.04 as=0.10875 ps=1.04 w=0.75 l=2
X791 OUT.t321 VIN.t704 VIN.t705 VIN.t108 sky130_fd_pr__pfet_01v8 ad=0.1421 pd=1.56 as=0.1421 ps=1.56 w=0.49 l=0.2
X792 OUT.t320 VIN.t702 VIN.t703 VIN.t69 sky130_fd_pr__pfet_01v8 ad=0.1421 pd=1.56 as=0.1421 ps=1.56 w=0.49 l=0.2
X793 VIN.t701 VIN.t700 OUT.t319 VIN.t360 sky130_fd_pr__pfet_01v8 ad=0.1421 pd=1.56 as=0.1421 ps=1.56 w=0.49 l=0.2
X794 VIN.t699 VIN.t698 OUT.t318 VIN.t66 sky130_fd_pr__pfet_01v8 ad=0.1421 pd=1.56 as=0.1421 ps=1.56 w=0.49 l=0.2
X795 VIN.t697 VIN.t696 OUT.t317 VIN.t63 sky130_fd_pr__pfet_01v8 ad=0.1421 pd=1.56 as=0.1421 ps=1.56 w=0.49 l=0.2
X796 VIN.t2127 bias-network_0.IBIAS2.t19 a_816_4748.t11 VIN.t2126 sky130_fd_pr__pfet_01v8 ad=0.23925 pd=1.94 as=0.23925 ps=1.94 w=1.65 l=0.6
X797 OUT.t316 VIN.t694 VIN.t695 VIN.t43 sky130_fd_pr__pfet_01v8 ad=0.1421 pd=1.56 as=0.1421 ps=1.56 w=0.49 l=0.2
X798 VIN.t693 VIN.t692 OUT.t315 VIN.t95 sky130_fd_pr__pfet_01v8 ad=0.1421 pd=1.56 as=0.1421 ps=1.56 w=0.49 l=0.2
X799 OUT.t314 VIN.t690 VIN.t691 VIN.t16 sky130_fd_pr__pfet_01v8 ad=0.1421 pd=1.56 as=0.1421 ps=1.56 w=0.49 l=0.2
X800 OUT.t313 VIN.t688 VIN.t689 VIN.t87 sky130_fd_pr__pfet_01v8 ad=0.1421 pd=1.56 as=0.1421 ps=1.56 w=0.49 l=0.2
X801 OUT.t312 VIN.t686 VIN.t687 VIN.t69 sky130_fd_pr__pfet_01v8 ad=0.1421 pd=1.56 as=0.1421 ps=1.56 w=0.49 l=0.2
X802 VIN.t685 VIN.t684 OUT.t311 VIN.t82 sky130_fd_pr__pfet_01v8 ad=0.1421 pd=1.56 as=0.1421 ps=1.56 w=0.49 l=0.2
X803 VIN.t683 VIN.t682 OUT.t310 VIN.t313 sky130_fd_pr__pfet_01v8 ad=0.1421 pd=1.56 as=0.1421 ps=1.56 w=0.49 l=0.2
X804 VIN.t681 VIN.t680 OUT.t309 VIN.t49 sky130_fd_pr__pfet_01v8 ad=0.1421 pd=1.56 as=0.1421 ps=1.56 w=0.49 l=0.2
X805 VIN.t679 VIN.t678 OUT.t308 VIN.t75 sky130_fd_pr__pfet_01v8 ad=0.1421 pd=1.56 as=0.1421 ps=1.56 w=0.49 l=0.2
X806 VIN.t677 VIN.t676 OUT.t307 VIN.t127 sky130_fd_pr__pfet_01v8 ad=0.1421 pd=1.56 as=0.1421 ps=1.56 w=0.49 l=0.2
X807 VIN.t675 VIN.t674 OUT.t306 VIN.t111 sky130_fd_pr__pfet_01v8 ad=0.1421 pd=1.56 as=0.1421 ps=1.56 w=0.49 l=0.2
X808 a_9732_2090# a_9552_310# VSS.t69 sky130_fd_pr__res_xhigh_po_0p69 l=6.9
X809 VIN.t673 VIN.t672 OUT.t305 VIN.t228 sky130_fd_pr__pfet_01v8 ad=0.1421 pd=1.56 as=0.1421 ps=1.56 w=0.49 l=0.2
X810 OUT.t304 VIN.t670 VIN.t671 VIN.t138 sky130_fd_pr__pfet_01v8 ad=0.1421 pd=1.56 as=0.1421 ps=1.56 w=0.49 l=0.2
X811 OUT.t303 VIN.t668 VIN.t669 VIN.t69 sky130_fd_pr__pfet_01v8 ad=0.1421 pd=1.56 as=0.1421 ps=1.56 w=0.49 l=0.2
X812 VIN.t667 VIN.t666 OUT.t302 VIN.t55 sky130_fd_pr__pfet_01v8 ad=0.1421 pd=1.56 as=0.1421 ps=1.56 w=0.49 l=0.2
X813 a_100_2480# a_500_700# VSS.t70 sky130_fd_pr__res_xhigh_po_0p69 l=6.9
X814 OUT.t301 VIN.t664 VIN.t665 VIN.t324 sky130_fd_pr__pfet_01v8 ad=0.1421 pd=1.56 as=0.1421 ps=1.56 w=0.49 l=0.2
X815 VIN.t663 VIN.t662 OUT.t300 VIN.t49 sky130_fd_pr__pfet_01v8 ad=0.1421 pd=1.56 as=0.1421 ps=1.56 w=0.49 l=0.2
X816 VIN.t661 VIN.t660 OUT.t299 VIN.t82 sky130_fd_pr__pfet_01v8 ad=0.1421 pd=1.56 as=0.1421 ps=1.56 w=0.49 l=0.2
X817 VIN.t659 VIN.t658 OUT.t298 VIN.t28 sky130_fd_pr__pfet_01v8 ad=0.1421 pd=1.56 as=0.1421 ps=1.56 w=0.49 l=0.2
X818 OUT.t297 VIN.t656 VIN.t657 VIN.t34 sky130_fd_pr__pfet_01v8 ad=0.1421 pd=1.56 as=0.1421 ps=1.56 w=0.49 l=0.2
X819 VIN.t655 VIN.t654 OUT.t296 VIN.t75 sky130_fd_pr__pfet_01v8 ad=0.1421 pd=1.56 as=0.1421 ps=1.56 w=0.49 l=0.2
X820 OUT.t295 VIN.t652 VIN.t653 VIN.t426 sky130_fd_pr__pfet_01v8 ad=0.1421 pd=1.56 as=0.1421 ps=1.56 w=0.49 l=0.2
X821 a_10152_2090# a_9952_310# VSS.t71 sky130_fd_pr__res_xhigh_po_0p69 l=6.9
X822 OUT.t294 VIN.t650 VIN.t651 VIN.t339 sky130_fd_pr__pfet_01v8 ad=0.1421 pd=1.56 as=0.1421 ps=1.56 w=0.49 l=0.2
X823 OUT.t293 VIN.t648 VIN.t649 VIN.t19 sky130_fd_pr__pfet_01v8 ad=0.1421 pd=1.56 as=0.1421 ps=1.56 w=0.49 l=0.2
X824 OUT.t292 VIN.t646 VIN.t647 VIN.t7 sky130_fd_pr__pfet_01v8 ad=0.1421 pd=1.56 as=0.1421 ps=1.56 w=0.49 l=0.2
X825 VIN.t645 VIN.t644 OUT.t291 VIN.t66 sky130_fd_pr__pfet_01v8 ad=0.1421 pd=1.56 as=0.1421 ps=1.56 w=0.49 l=0.2
X826 OUT.t290 VIN.t642 VIN.t643 VIN.t167 sky130_fd_pr__pfet_01v8 ad=0.1421 pd=1.56 as=0.1421 ps=1.56 w=0.49 l=0.2
X827 VIN.t641 VIN.t640 OUT.t289 VIN.t10 sky130_fd_pr__pfet_01v8 ad=0.1421 pd=1.56 as=0.1421 ps=1.56 w=0.49 l=0.2
X828 OUT.t288 VIN.t638 VIN.t639 VIN.t138 sky130_fd_pr__pfet_01v8 ad=0.1421 pd=1.56 as=0.1421 ps=1.56 w=0.49 l=0.2
X829 VIN.t637 VIN.t636 OUT.t287 VIN.t37 sky130_fd_pr__pfet_01v8 ad=0.1421 pd=1.56 as=0.1421 ps=1.56 w=0.49 l=0.2
X830 OUT.t286 VIN.t634 VIN.t635 VIN.t141 sky130_fd_pr__pfet_01v8 ad=0.1421 pd=1.56 as=0.1421 ps=1.56 w=0.49 l=0.2
X831 OUT.t285 VIN.t632 VIN.t633 VIN.t22 sky130_fd_pr__pfet_01v8 ad=0.1421 pd=1.56 as=0.1421 ps=1.56 w=0.49 l=0.2
X832 OUT.t284 VIN.t630 VIN.t631 VIN.t98 sky130_fd_pr__pfet_01v8 ad=0.1421 pd=1.56 as=0.1421 ps=1.56 w=0.49 l=0.2
X833 VIN.t629 VIN.t628 OUT.t283 VIN.t10 sky130_fd_pr__pfet_01v8 ad=0.1421 pd=1.56 as=0.1421 ps=1.56 w=0.49 l=0.2
X834 OUT.t282 VIN.t626 VIN.t627 VIN.t52 sky130_fd_pr__pfet_01v8 ad=0.1421 pd=1.56 as=0.1421 ps=1.56 w=0.49 l=0.2
X835 OUT.t281 VIN.t624 VIN.t625 VIN.t278 sky130_fd_pr__pfet_01v8 ad=0.1421 pd=1.56 as=0.1421 ps=1.56 w=0.49 l=0.2
X836 OUT.t280 VIN.t622 VIN.t623 VIN.t155 sky130_fd_pr__pfet_01v8 ad=0.1421 pd=1.56 as=0.1421 ps=1.56 w=0.49 l=0.2
X837 OUT.t279 VIN.t620 VIN.t621 VIN.t31 sky130_fd_pr__pfet_01v8 ad=0.1421 pd=1.56 as=0.1421 ps=1.56 w=0.49 l=0.2
X838 VIN.t619 VIN.t618 OUT.t278 VIN.t66 sky130_fd_pr__pfet_01v8 ad=0.1421 pd=1.56 as=0.1421 ps=1.56 w=0.49 l=0.2
X839 VIN.t617 VIN.t616 OUT.t277 VIN.t360 sky130_fd_pr__pfet_01v8 ad=0.1421 pd=1.56 as=0.1421 ps=1.56 w=0.49 l=0.2
X840 a_900_2480# a_500_700# VSS.t72 sky130_fd_pr__res_xhigh_po_0p69 l=6.9
X841 a_900_2480# a_1300_700# VSS.t73 sky130_fd_pr__res_xhigh_po_0p69 l=6.9
X842 OUT.t276 VIN.t614 VIN.t615 VIN.t278 sky130_fd_pr__pfet_01v8 ad=0.1421 pd=1.56 as=0.1421 ps=1.56 w=0.49 l=0.2
X843 OUT.t275 VIN.t612 VIN.t613 VIN.t301 sky130_fd_pr__pfet_01v8 ad=0.1421 pd=1.56 as=0.1421 ps=1.56 w=0.49 l=0.2
X844 VIN.t611 VIN.t610 OUT.t274 VIN.t127 sky130_fd_pr__pfet_01v8 ad=0.1421 pd=1.56 as=0.1421 ps=1.56 w=0.49 l=0.2
X845 OUT.t273 VIN.t608 VIN.t609 VIN.t306 sky130_fd_pr__pfet_01v8 ad=0.1421 pd=1.56 as=0.1421 ps=1.56 w=0.49 l=0.2
X846 VIN.t607 VIN.t606 OUT.t272 VIN.t124 sky130_fd_pr__pfet_01v8 ad=0.1421 pd=1.56 as=0.1421 ps=1.56 w=0.49 l=0.2
X847 OUT.t271 VIN.t604 VIN.t605 VIN.t119 sky130_fd_pr__pfet_01v8 ad=0.1421 pd=1.56 as=0.1421 ps=1.56 w=0.49 l=0.2
X848 OUT.t270 VIN.t602 VIN.t603 VIN.t278 sky130_fd_pr__pfet_01v8 ad=0.1421 pd=1.56 as=0.1421 ps=1.56 w=0.49 l=0.2
X849 OUT.t269 VIN.t600 VIN.t601 VIN.t72 sky130_fd_pr__pfet_01v8 ad=0.1421 pd=1.56 as=0.1421 ps=1.56 w=0.49 l=0.2
X850 OUT.t268 VIN.t598 VIN.t599 VIN.t155 sky130_fd_pr__pfet_01v8 ad=0.1421 pd=1.56 as=0.1421 ps=1.56 w=0.49 l=0.2
X851 OUT.t267 VIN.t596 VIN.t597 VIN.t185 sky130_fd_pr__pfet_01v8 ad=0.1421 pd=1.56 as=0.1421 ps=1.56 w=0.49 l=0.2
X852 VIN.t595 VIN.t594 OUT.t266 VIN.t92 sky130_fd_pr__pfet_01v8 ad=0.1421 pd=1.56 as=0.1421 ps=1.56 w=0.49 l=0.2
X853 VIN.t593 VIN.t592 OUT.t265 VIN.t233 sky130_fd_pr__pfet_01v8 ad=0.1421 pd=1.56 as=0.1421 ps=1.56 w=0.49 l=0.2
X854 VIN.t591 VIN.t590 OUT.t264 VIN.t49 sky130_fd_pr__pfet_01v8 ad=0.1421 pd=1.56 as=0.1421 ps=1.56 w=0.49 l=0.2
X855 VIN.t589 VIN.t588 OUT.t263 VIN.t82 sky130_fd_pr__pfet_01v8 ad=0.1421 pd=1.56 as=0.1421 ps=1.56 w=0.49 l=0.2
X856 OUT.t262 VIN.t586 VIN.t587 VIN.t339 sky130_fd_pr__pfet_01v8 ad=0.1421 pd=1.56 as=0.1421 ps=1.56 w=0.49 l=0.2
X857 OUT.t261 VIN.t584 VIN.t585 VIN.t426 sky130_fd_pr__pfet_01v8 ad=0.1421 pd=1.56 as=0.1421 ps=1.56 w=0.49 l=0.2
X858 OUT.t260 VIN.t582 VIN.t583 VIN.t269 sky130_fd_pr__pfet_01v8 ad=0.1421 pd=1.56 as=0.1421 ps=1.56 w=0.49 l=0.2
X859 VIN.t581 VIN.t580 OUT.t259 VIN.t395 sky130_fd_pr__pfet_01v8 ad=0.1421 pd=1.56 as=0.1421 ps=1.56 w=0.49 l=0.2
X860 VIN.t579 VIN.t578 OUT.t258 VIN.t95 sky130_fd_pr__pfet_01v8 ad=0.1421 pd=1.56 as=0.1421 ps=1.56 w=0.49 l=0.2
X861 VIN.t577 VIN.t576 OUT.t257 VIN.t233 sky130_fd_pr__pfet_01v8 ad=0.1421 pd=1.56 as=0.1421 ps=1.56 w=0.49 l=0.2
X862 VIN.t575 VIN.t574 OUT.t256 VIN.t101 sky130_fd_pr__pfet_01v8 ad=0.1421 pd=1.56 as=0.1421 ps=1.56 w=0.49 l=0.2
X863 VIN.t573 VIN.t572 OUT.t255 VIN.t161 sky130_fd_pr__pfet_01v8 ad=0.1421 pd=1.56 as=0.1421 ps=1.56 w=0.49 l=0.2
X864 VIN.t571 VIN.t570 OUT.t254 VIN.t92 sky130_fd_pr__pfet_01v8 ad=0.1421 pd=1.56 as=0.1421 ps=1.56 w=0.49 l=0.2
X865 VIN.t569 VIN.t568 OUT.t253 VIN.t124 sky130_fd_pr__pfet_01v8 ad=0.1421 pd=1.56 as=0.1421 ps=1.56 w=0.49 l=0.2
X866 bias-network_0.IBIAS2.t5 bias-network_0.VREF.t32 VSS.t28 VSS.t26 sky130_fd_pr__nfet_01v8 ad=0.10875 pd=1.04 as=0.10875 ps=1.04 w=0.75 l=2
X867 VIN.t567 VIN.t566 OUT.t252 VIN.t395 sky130_fd_pr__pfet_01v8 ad=0.1421 pd=1.56 as=0.1421 ps=1.56 w=0.49 l=0.2
X868 VIN.t565 VIN.t564 OUT.t251 VIN.t111 sky130_fd_pr__pfet_01v8 ad=0.1421 pd=1.56 as=0.1421 ps=1.56 w=0.49 l=0.2
X869 OUT.t250 VIN.t562 VIN.t563 VIN.t22 sky130_fd_pr__pfet_01v8 ad=0.1421 pd=1.56 as=0.1421 ps=1.56 w=0.49 l=0.2
X870 VIN.t561 VIN.t560 OUT.t249 VIN.t228 sky130_fd_pr__pfet_01v8 ad=0.1421 pd=1.56 as=0.1421 ps=1.56 w=0.49 l=0.2
X871 VIN.t2135 bias-network_0.VREF.t33 a_3816_4748.t9 VIN.t2134 sky130_fd_pr__pfet_01v8 ad=1.015 pd=7.29 as=1.015 ps=7.29 w=7 l=0.6
X872 a_1700_2480# a_1300_700# VSS.t76 sky130_fd_pr__res_xhigh_po_0p69 l=6.9
X873 bias-network_0.IBIAS2.t4 bias-network_0.VREF.t34 VSS.t27 VSS.t26 sky130_fd_pr__nfet_01v8 ad=0.10875 pd=1.04 as=0.10875 ps=1.04 w=0.75 l=2
X874 OUT.t248 VIN.t558 VIN.t559 VIN.t16 sky130_fd_pr__pfet_01v8 ad=0.1421 pd=1.56 as=0.1421 ps=1.56 w=0.49 l=0.2
X875 OUT.t247 VIN.t556 VIN.t557 VIN.t13 sky130_fd_pr__pfet_01v8 ad=0.1421 pd=1.56 as=0.1421 ps=1.56 w=0.49 l=0.2
X876 VIN.t555 VIN.t554 OUT.t246 VIN.t40 sky130_fd_pr__pfet_01v8 ad=0.1421 pd=1.56 as=0.1421 ps=1.56 w=0.49 l=0.2
X877 OUT.t245 VIN.t552 VIN.t553 VIN.t119 sky130_fd_pr__pfet_01v8 ad=0.1421 pd=1.56 as=0.1421 ps=1.56 w=0.49 l=0.2
X878 OUT.t244 VIN.t550 VIN.t551 VIN.t52 sky130_fd_pr__pfet_01v8 ad=0.1421 pd=1.56 as=0.1421 ps=1.56 w=0.49 l=0.2
X879 VIN.t549 VIN.t548 OUT.t243 VIN.t37 sky130_fd_pr__pfet_01v8 ad=0.1421 pd=1.56 as=0.1421 ps=1.56 w=0.49 l=0.2
X880 OUT.t242 VIN.t546 VIN.t547 VIN.t43 sky130_fd_pr__pfet_01v8 ad=0.1421 pd=1.56 as=0.1421 ps=1.56 w=0.49 l=0.2
X881 VIN.t545 VIN.t544 OUT.t241 VIN.t360 sky130_fd_pr__pfet_01v8 ad=0.1421 pd=1.56 as=0.1421 ps=1.56 w=0.49 l=0.2
X882 OUT.t240 VIN.t542 VIN.t543 VIN.t324 sky130_fd_pr__pfet_01v8 ad=0.1421 pd=1.56 as=0.1421 ps=1.56 w=0.49 l=0.2
X883 OUT.t239 VIN.t540 VIN.t541 VIN.t43 sky130_fd_pr__pfet_01v8 ad=0.1421 pd=1.56 as=0.1421 ps=1.56 w=0.49 l=0.2
X884 VIN.t539 VIN.t538 OUT.t238 VIN.t161 sky130_fd_pr__pfet_01v8 ad=0.1421 pd=1.56 as=0.1421 ps=1.56 w=0.49 l=0.2
X885 VIN.t537 VIN.t536 OUT.t237 VIN.t95 sky130_fd_pr__pfet_01v8 ad=0.1421 pd=1.56 as=0.1421 ps=1.56 w=0.49 l=0.2
X886 OUT.t236 VIN.t534 VIN.t535 VIN.t167 sky130_fd_pr__pfet_01v8 ad=0.1421 pd=1.56 as=0.1421 ps=1.56 w=0.49 l=0.2
X887 VIN.t533 VIN.t532 OUT.t235 VIN.t25 sky130_fd_pr__pfet_01v8 ad=0.1421 pd=1.56 as=0.1421 ps=1.56 w=0.49 l=0.2
X888 VIN.t531 VIN.t530 OUT.t234 VIN.t313 sky130_fd_pr__pfet_01v8 ad=0.1421 pd=1.56 as=0.1421 ps=1.56 w=0.49 l=0.2
X889 OUT.t233 VIN.t528 VIN.t529 VIN.t87 sky130_fd_pr__pfet_01v8 ad=0.1421 pd=1.56 as=0.1421 ps=1.56 w=0.49 l=0.2
X890 OUT.t232 VIN.t526 VIN.t527 VIN.t141 sky130_fd_pr__pfet_01v8 ad=0.1421 pd=1.56 as=0.1421 ps=1.56 w=0.49 l=0.2
X891 VIN.t525 VIN.t524 OUT.t231 VIN.t313 sky130_fd_pr__pfet_01v8 ad=0.1421 pd=1.56 as=0.1421 ps=1.56 w=0.49 l=0.2
X892 VIN.t523 VIN.t522 OUT.t230 VIN.t127 sky130_fd_pr__pfet_01v8 ad=0.1421 pd=1.56 as=0.1421 ps=1.56 w=0.49 l=0.2
X893 OUT.t229 VIN.t520 VIN.t521 VIN.t4 sky130_fd_pr__pfet_01v8 ad=0.1421 pd=1.56 as=0.1421 ps=1.56 w=0.49 l=0.2
X894 OUT.t228 VIN.t518 VIN.t519 VIN.t52 sky130_fd_pr__pfet_01v8 ad=0.1421 pd=1.56 as=0.1421 ps=1.56 w=0.49 l=0.2
X895 OUT.t227 VIN.t516 VIN.t517 VIN.t301 sky130_fd_pr__pfet_01v8 ad=0.1421 pd=1.56 as=0.1421 ps=1.56 w=0.49 l=0.2
X896 VIN.t515 VIN.t514 OUT.t226 VIN.t130 sky130_fd_pr__pfet_01v8 ad=0.1421 pd=1.56 as=0.1421 ps=1.56 w=0.49 l=0.2
X897 a_9352_2090# a_9552_310# VSS.t77 sky130_fd_pr__res_xhigh_po_0p69 l=6.9
X898 VIN.t513 VIN.t512 OUT.t225 VIN.t25 sky130_fd_pr__pfet_01v8 ad=0.1421 pd=1.56 as=0.1421 ps=1.56 w=0.49 l=0.2
X899 OUT.t224 VIN.t510 VIN.t511 VIN.t324 sky130_fd_pr__pfet_01v8 ad=0.1421 pd=1.56 as=0.1421 ps=1.56 w=0.49 l=0.2
X900 VIN.t509 VIN.t508 OUT.t223 VIN.t55 sky130_fd_pr__pfet_01v8 ad=0.1421 pd=1.56 as=0.1421 ps=1.56 w=0.49 l=0.2
X901 VIN.t507 VIN.t506 OUT.t222 VIN.t28 sky130_fd_pr__pfet_01v8 ad=0.1421 pd=1.56 as=0.1421 ps=1.56 w=0.49 l=0.2
X902 OUT.t221 VIN.t504 VIN.t505 VIN.t141 sky130_fd_pr__pfet_01v8 ad=0.1421 pd=1.56 as=0.1421 ps=1.56 w=0.49 l=0.2
X903 OUT.t220 VIN.t502 VIN.t503 VIN.t306 sky130_fd_pr__pfet_01v8 ad=0.1421 pd=1.56 as=0.1421 ps=1.56 w=0.49 l=0.2
X904 OUT.t219 VIN.t500 VIN.t501 VIN.t339 sky130_fd_pr__pfet_01v8 ad=0.1421 pd=1.56 as=0.1421 ps=1.56 w=0.49 l=0.2
X905 OUT.t218 VIN.t498 VIN.t499 VIN.t426 sky130_fd_pr__pfet_01v8 ad=0.1421 pd=1.56 as=0.1421 ps=1.56 w=0.49 l=0.2
X906 VIN.t497 VIN.t496 OUT.t217 VIN.t178 sky130_fd_pr__pfet_01v8 ad=0.1421 pd=1.56 as=0.1421 ps=1.56 w=0.49 l=0.2
X907 OUT.t216 VIN.t494 VIN.t495 VIN.t301 sky130_fd_pr__pfet_01v8 ad=0.1421 pd=1.56 as=0.1421 ps=1.56 w=0.49 l=0.2
X908 VSS.t104 a_638_4130.t6 a_638_4130.t7 VSS.t103 sky130_fd_pr__nfet_01v8 ad=0.15225 pd=1.34 as=0.15225 ps=1.34 w=1.05 l=0.6
X909 a_638_4130.t1 error-amplifier_0.VN a_816_4748.t5 VIN.t2113 sky130_fd_pr__pfet_01v8 ad=1.015 pd=7.29 as=1.015 ps=7.29 w=7 l=0.6
X910 OUT.t215 VIN.t492 VIN.t493 VIN.t19 sky130_fd_pr__pfet_01v8 ad=0.1421 pd=1.56 as=0.1421 ps=1.56 w=0.49 l=0.2
X911 OUT.t214 VIN.t490 VIN.t491 VIN.t185 sky130_fd_pr__pfet_01v8 ad=0.1421 pd=1.56 as=0.1421 ps=1.56 w=0.49 l=0.2
X912 VIN.t489 VIN.t488 OUT.t213 VIN.t190 sky130_fd_pr__pfet_01v8 ad=0.1421 pd=1.56 as=0.1421 ps=1.56 w=0.49 l=0.2
X913 VIN.t487 VIN.t486 OUT.t212 VIN.t37 sky130_fd_pr__pfet_01v8 ad=0.1421 pd=1.56 as=0.1421 ps=1.56 w=0.49 l=0.2
X914 OUT.t211 VIN.t484 VIN.t485 VIN.t98 sky130_fd_pr__pfet_01v8 ad=0.1421 pd=1.56 as=0.1421 ps=1.56 w=0.49 l=0.2
X915 VIN.t483 VIN.t482 OUT.t210 VIN.t92 sky130_fd_pr__pfet_01v8 ad=0.1421 pd=1.56 as=0.1421 ps=1.56 w=0.49 l=0.2
X916 VIN.t481 VIN.t480 OUT.t209 VIN.t10 sky130_fd_pr__pfet_01v8 ad=0.1421 pd=1.56 as=0.1421 ps=1.56 w=0.49 l=0.2
X917 OUT.t208 VIN.t478 VIN.t479 VIN.t7 sky130_fd_pr__pfet_01v8 ad=0.1421 pd=1.56 as=0.1421 ps=1.56 w=0.49 l=0.2
X918 bias-network_0.IBIAS2.t9 bias-network_0.IBIAS2.t8 VIN.t2116 VIN.t2114 sky130_fd_pr__pfet_01v8 ad=0.4785 pd=3.88 as=0.23925 ps=1.94 w=1.65 l=0.6
X919 VIN.t477 VIN.t476 OUT.t207 VIN.t10 sky130_fd_pr__pfet_01v8 ad=0.1421 pd=1.56 as=0.1421 ps=1.56 w=0.49 l=0.2
X920 VIN.t475 VIN.t474 OUT.t206 VIN.t82 sky130_fd_pr__pfet_01v8 ad=0.1421 pd=1.56 as=0.1421 ps=1.56 w=0.49 l=0.2
X921 VIN.t473 VIN.t472 OUT.t205 VIN.t144 sky130_fd_pr__pfet_01v8 ad=0.1421 pd=1.56 as=0.1421 ps=1.56 w=0.49 l=0.2
X922 OUT.t204 VIN.t470 VIN.t471 VIN.t301 sky130_fd_pr__pfet_01v8 ad=0.1421 pd=1.56 as=0.1421 ps=1.56 w=0.49 l=0.2
X923 VSS.t116 a_638_4130.t15 bias-network_0.IBIAS1.t15 VSS.t115 sky130_fd_pr__nfet_01v8 ad=0.15225 pd=1.34 as=0.15225 ps=1.34 w=1.05 l=0.6
X924 OUT.t203 VIN.t468 VIN.t469 VIN.t98 sky130_fd_pr__pfet_01v8 ad=0.1421 pd=1.56 as=0.1421 ps=1.56 w=0.49 l=0.2
X925 OUT.t202 VIN.t466 VIN.t467 VIN.t269 sky130_fd_pr__pfet_01v8 ad=0.1421 pd=1.56 as=0.1421 ps=1.56 w=0.49 l=0.2
X926 OUT.t201 VIN.t464 VIN.t465 VIN.t138 sky130_fd_pr__pfet_01v8 ad=0.1421 pd=1.56 as=0.1421 ps=1.56 w=0.49 l=0.2
X927 OUT.t200 VIN.t462 VIN.t463 VIN.t185 sky130_fd_pr__pfet_01v8 ad=0.1421 pd=1.56 as=0.1421 ps=1.56 w=0.49 l=0.2
X928 VIN.t461 VIN.t460 OUT.t199 VIN.t395 sky130_fd_pr__pfet_01v8 ad=0.1421 pd=1.56 as=0.1421 ps=1.56 w=0.49 l=0.2
X929 OUT.t198 VIN.t458 VIN.t459 VIN.t158 sky130_fd_pr__pfet_01v8 ad=0.1421 pd=1.56 as=0.1421 ps=1.56 w=0.49 l=0.2
X930 VIN.t457 VIN.t456 OUT.t197 VIN.t135 sky130_fd_pr__pfet_01v8 ad=0.1421 pd=1.56 as=0.1421 ps=1.56 w=0.49 l=0.2
X931 OUT.t196 VIN.t454 VIN.t455 VIN.t278 sky130_fd_pr__pfet_01v8 ad=0.1421 pd=1.56 as=0.1421 ps=1.56 w=0.49 l=0.2
X932 VIN.t453 VIN.t452 OUT.t195 VIN.t240 sky130_fd_pr__pfet_01v8 ad=0.1421 pd=1.56 as=0.1421 ps=1.56 w=0.49 l=0.2
X933 VIN.t451 VIN.t450 OUT.t194 VIN.t127 sky130_fd_pr__pfet_01v8 ad=0.1421 pd=1.56 as=0.1421 ps=1.56 w=0.49 l=0.2
X934 VIN.t449 VIN.t448 OUT.t193 VIN.t135 sky130_fd_pr__pfet_01v8 ad=0.1421 pd=1.56 as=0.1421 ps=1.56 w=0.49 l=0.2
X935 VIN.t447 VIN.t446 OUT.t192 VIN.t233 sky130_fd_pr__pfet_01v8 ad=0.1421 pd=1.56 as=0.1421 ps=1.56 w=0.49 l=0.2
X936 OUT.t191 VIN.t444 VIN.t445 VIN.t16 sky130_fd_pr__pfet_01v8 ad=0.1421 pd=1.56 as=0.1421 ps=1.56 w=0.49 l=0.2
X937 OUT.t190 VIN.t442 VIN.t443 VIN.t13 sky130_fd_pr__pfet_01v8 ad=0.1421 pd=1.56 as=0.1421 ps=1.56 w=0.49 l=0.2
X938 OUT.t189 VIN.t440 VIN.t441 VIN.t72 sky130_fd_pr__pfet_01v8 ad=0.1421 pd=1.56 as=0.1421 ps=1.56 w=0.49 l=0.2
X939 VIN.t439 VIN.t438 OUT.t188 VIN.t190 sky130_fd_pr__pfet_01v8 ad=0.1421 pd=1.56 as=0.1421 ps=1.56 w=0.49 l=0.2
X940 VIN.t437 VIN.t436 OUT.t187 VIN.t49 sky130_fd_pr__pfet_01v8 ad=0.1421 pd=1.56 as=0.1421 ps=1.56 w=0.49 l=0.2
X941 VIN.t435 VIN.t434 OUT.t186 VIN.t95 sky130_fd_pr__pfet_01v8 ad=0.1421 pd=1.56 as=0.1421 ps=1.56 w=0.49 l=0.2
X942 OUT.t185 VIN.t432 VIN.t433 VIN.t269 sky130_fd_pr__pfet_01v8 ad=0.1421 pd=1.56 as=0.1421 ps=1.56 w=0.49 l=0.2
X943 OUT.t184 VIN.t430 VIN.t431 VIN.t43 sky130_fd_pr__pfet_01v8 ad=0.1421 pd=1.56 as=0.1421 ps=1.56 w=0.49 l=0.2
X944 VIN.t429 VIN.t428 OUT.t183 VIN.t395 sky130_fd_pr__pfet_01v8 ad=0.1421 pd=1.56 as=0.1421 ps=1.56 w=0.49 l=0.2
X945 OUT.t182 VIN.t425 VIN.t427 VIN.t426 sky130_fd_pr__pfet_01v8 ad=0.1421 pd=1.56 as=0.1421 ps=1.56 w=0.49 l=0.2
X946 VIN.t424 VIN.t423 OUT.t181 VIN.t395 sky130_fd_pr__pfet_01v8 ad=0.1421 pd=1.56 as=0.1421 ps=1.56 w=0.49 l=0.2
X947 VIN.t2141 bias-network_0.IBIAS1.t0 bias-network_0.IBIAS1.t1 VIN.t2140 sky130_fd_pr__pfet_01v8 ad=0.23925 pd=1.94 as=0.4785 ps=3.88 w=1.65 l=0.6
X948 VIN.t422 VIN.t421 OUT.t180 VIN.t40 sky130_fd_pr__pfet_01v8 ad=0.1421 pd=1.56 as=0.1421 ps=1.56 w=0.49 l=0.2
X949 OUT.t179 VIN.t419 VIN.t420 VIN.t31 sky130_fd_pr__pfet_01v8 ad=0.1421 pd=1.56 as=0.1421 ps=1.56 w=0.49 l=0.2
X950 OUT.t178 VIN.t417 VIN.t418 VIN.t339 sky130_fd_pr__pfet_01v8 ad=0.1421 pd=1.56 as=0.1421 ps=1.56 w=0.49 l=0.2
X951 VIN.t416 VIN.t415 OUT.t177 VIN.t46 sky130_fd_pr__pfet_01v8 ad=0.1421 pd=1.56 as=0.1421 ps=1.56 w=0.49 l=0.2
X952 VIN.t414 VIN.t413 OUT.t176 VIN.t233 sky130_fd_pr__pfet_01v8 ad=0.1421 pd=1.56 as=0.1421 ps=1.56 w=0.49 l=0.2
X953 VIN.t412 VIN.t411 OUT.t175 VIN.t228 sky130_fd_pr__pfet_01v8 ad=0.1421 pd=1.56 as=0.1421 ps=1.56 w=0.49 l=0.2
X954 a_8952_2090# a_8752_310# VSS.t78 sky130_fd_pr__res_xhigh_po_0p69 l=6.9
X955 VIN.t410 VIN.t409 OUT.t174 VIN.t211 sky130_fd_pr__pfet_01v8 ad=0.1421 pd=1.56 as=0.1421 ps=1.56 w=0.49 l=0.2
X956 VIN.t408 VIN.t407 OUT.t173 VIN.t313 sky130_fd_pr__pfet_01v8 ad=0.1421 pd=1.56 as=0.1421 ps=1.56 w=0.49 l=0.2
X957 OUT.t172 VIN.t405 VIN.t406 VIN.t13 sky130_fd_pr__pfet_01v8 ad=0.1421 pd=1.56 as=0.1421 ps=1.56 w=0.49 l=0.2
X958 VIN.t404 VIN.t403 OUT.t171 VIN.t127 sky130_fd_pr__pfet_01v8 ad=0.1421 pd=1.56 as=0.1421 ps=1.56 w=0.49 l=0.2
X959 VIN.t402 VIN.t401 OUT.t170 VIN.t111 sky130_fd_pr__pfet_01v8 ad=0.1421 pd=1.56 as=0.1421 ps=1.56 w=0.49 l=0.2
X960 OUT.t169 VIN.t399 VIN.t400 VIN.t4 sky130_fd_pr__pfet_01v8 ad=0.1421 pd=1.56 as=0.1421 ps=1.56 w=0.49 l=0.2
X961 OUT.t168 VIN.t397 VIN.t398 VIN.t22 sky130_fd_pr__pfet_01v8 ad=0.1421 pd=1.56 as=0.1421 ps=1.56 w=0.49 l=0.2
X962 VIN.t396 VIN.t394 OUT.t167 VIN.t395 sky130_fd_pr__pfet_01v8 ad=0.1421 pd=1.56 as=0.1421 ps=1.56 w=0.49 l=0.2
X963 OUT.t166 VIN.t392 VIN.t393 VIN.t43 sky130_fd_pr__pfet_01v8 ad=0.1421 pd=1.56 as=0.1421 ps=1.56 w=0.49 l=0.2
X964 OUT.t165 VIN.t390 VIN.t391 VIN.t185 sky130_fd_pr__pfet_01v8 ad=0.1421 pd=1.56 as=0.1421 ps=1.56 w=0.49 l=0.2
X965 VSS.t25 bias-network_0.VREF.t2 bias-network_0.VREF.t3 VSS.t19 sky130_fd_pr__nfet_01v8 ad=0.10875 pd=1.04 as=0.10875 ps=1.04 w=0.75 l=2
X966 VSS.t24 bias-network_0.VREF.t35 bias-network_0.IBIAS2.t3 VSS.t21 sky130_fd_pr__nfet_01v8 ad=0.10875 pd=1.04 as=0.2175 ps=2.08 w=0.75 l=2
X967 bias-network_0.IBIAS2.t2 bias-network_0.VREF.t36 VSS.t23 VSS.t17 sky130_fd_pr__nfet_01v8 ad=0.2175 pd=2.08 as=0.10875 ps=1.04 w=0.75 l=2
X968 VIN.t389 VIN.t388 OUT.t164 VIN.t25 sky130_fd_pr__pfet_01v8 ad=0.1421 pd=1.56 as=0.1421 ps=1.56 w=0.49 l=0.2
X969 VIN.t387 VIN.t386 OUT.t163 VIN.t228 sky130_fd_pr__pfet_01v8 ad=0.1421 pd=1.56 as=0.1421 ps=1.56 w=0.49 l=0.2
X970 OUT.t162 VIN.t384 VIN.t385 VIN.t22 sky130_fd_pr__pfet_01v8 ad=0.1421 pd=1.56 as=0.1421 ps=1.56 w=0.49 l=0.2
X971 VIN.t383 VIN.t382 OUT.t161 VIN.t40 sky130_fd_pr__pfet_01v8 ad=0.1421 pd=1.56 as=0.1421 ps=1.56 w=0.49 l=0.2
X972 OUT.t160 VIN.t380 VIN.t381 VIN.t155 sky130_fd_pr__pfet_01v8 ad=0.1421 pd=1.56 as=0.1421 ps=1.56 w=0.49 l=0.2
X973 VIN.t379 VIN.t378 OUT.t159 VIN.t313 sky130_fd_pr__pfet_01v8 ad=0.1421 pd=1.56 as=0.1421 ps=1.56 w=0.49 l=0.2
X974 VIN.t377 VIN.t376 OUT.t158 VIN.t161 sky130_fd_pr__pfet_01v8 ad=0.1421 pd=1.56 as=0.1421 ps=1.56 w=0.49 l=0.2
X975 OUT.t157 VIN.t374 VIN.t375 VIN.t324 sky130_fd_pr__pfet_01v8 ad=0.1421 pd=1.56 as=0.1421 ps=1.56 w=0.49 l=0.2
X976 VSS.t22 bias-network_0.VREF.t37 bias-network_0.IBIAS2.t1 VSS.t21 sky130_fd_pr__nfet_01v8 ad=0.10875 pd=1.04 as=0.2175 ps=2.08 w=0.75 l=2
X977 OUT.t156 VIN.t372 VIN.t373 VIN.t339 sky130_fd_pr__pfet_01v8 ad=0.1421 pd=1.56 as=0.1421 ps=1.56 w=0.49 l=0.2
X978 VIN.t371 VIN.t370 OUT.t155 VIN.t46 sky130_fd_pr__pfet_01v8 ad=0.1421 pd=1.56 as=0.1421 ps=1.56 w=0.49 l=0.2
X979 OUT.t154 VIN.t368 VIN.t369 VIN.t43 sky130_fd_pr__pfet_01v8 ad=0.1421 pd=1.56 as=0.1421 ps=1.56 w=0.49 l=0.2
X980 VIN.t367 VIN.t366 OUT.t153 VIN.t127 sky130_fd_pr__pfet_01v8 ad=0.1421 pd=1.56 as=0.1421 ps=1.56 w=0.49 l=0.2
X981 VSS.t20 bias-network_0.VREF.t0 bias-network_0.VREF.t1 VSS.t19 sky130_fd_pr__nfet_01v8 ad=0.10875 pd=1.04 as=0.10875 ps=1.04 w=0.75 l=2
X982 bias-network_0.IBIAS2.t0 bias-network_0.VREF.t38 VSS.t18 VSS.t17 sky130_fd_pr__nfet_01v8 ad=0.2175 pd=2.08 as=0.10875 ps=1.04 w=0.75 l=2
X983 OUT.t152 VIN.t364 VIN.t365 VIN.t1 sky130_fd_pr__pfet_01v8 ad=0.1421 pd=1.56 as=0.1421 ps=1.56 w=0.49 l=0.2
X984 VIN.t363 VIN.t362 OUT.t151 VIN.t37 sky130_fd_pr__pfet_01v8 ad=0.1421 pd=1.56 as=0.1421 ps=1.56 w=0.49 l=0.2
X985 VIN.t361 VIN.t359 OUT.t150 VIN.t360 sky130_fd_pr__pfet_01v8 ad=0.1421 pd=1.56 as=0.1421 ps=1.56 w=0.49 l=0.2
X986 OUT.t149 VIN.t357 VIN.t358 VIN.t141 sky130_fd_pr__pfet_01v8 ad=0.1421 pd=1.56 as=0.1421 ps=1.56 w=0.49 l=0.2
X987 OUT.t148 VIN.t355 VIN.t356 VIN.t167 sky130_fd_pr__pfet_01v8 ad=0.1421 pd=1.56 as=0.1421 ps=1.56 w=0.49 l=0.2
X988 VIN.t354 VIN.t353 OUT.t147 VIN.t37 sky130_fd_pr__pfet_01v8 ad=0.1421 pd=1.56 as=0.1421 ps=1.56 w=0.49 l=0.2
X989 OUT.t146 VIN.t351 VIN.t352 VIN.t167 sky130_fd_pr__pfet_01v8 ad=0.1421 pd=1.56 as=0.1421 ps=1.56 w=0.49 l=0.2
X990 OUT.t145 VIN.t349 VIN.t350 VIN.t52 sky130_fd_pr__pfet_01v8 ad=0.1421 pd=1.56 as=0.1421 ps=1.56 w=0.49 l=0.2
X991 VIN.t348 VIN.t347 OUT.t144 VIN.t313 sky130_fd_pr__pfet_01v8 ad=0.1421 pd=1.56 as=0.1421 ps=1.56 w=0.49 l=0.2
X992 VIN.t346 VIN.t345 OUT.t143 VIN.t10 sky130_fd_pr__pfet_01v8 ad=0.1421 pd=1.56 as=0.1421 ps=1.56 w=0.49 l=0.2
X993 OUT.t142 VIN.t343 VIN.t344 VIN.t301 sky130_fd_pr__pfet_01v8 ad=0.1421 pd=1.56 as=0.1421 ps=1.56 w=0.49 l=0.2
X994 VIN.t342 VIN.t341 OUT.t141 VIN.t130 sky130_fd_pr__pfet_01v8 ad=0.1421 pd=1.56 as=0.1421 ps=1.56 w=0.49 l=0.2
X995 OUT.t140 VIN.t338 VIN.t340 VIN.t339 sky130_fd_pr__pfet_01v8 ad=0.1421 pd=1.56 as=0.1421 ps=1.56 w=0.49 l=0.2
X996 VIN.t337 VIN.t336 OUT.t139 VIN.t116 sky130_fd_pr__pfet_01v8 ad=0.1421 pd=1.56 as=0.1421 ps=1.56 w=0.49 l=0.2
X997 OUT.t138 VIN.t334 VIN.t335 VIN.t119 sky130_fd_pr__pfet_01v8 ad=0.1421 pd=1.56 as=0.1421 ps=1.56 w=0.49 l=0.2
X998 VIN.t333 VIN.t332 OUT.t137 VIN.t124 sky130_fd_pr__pfet_01v8 ad=0.1421 pd=1.56 as=0.1421 ps=1.56 w=0.49 l=0.2
X999 OUT.t136 VIN.t330 VIN.t331 VIN.t138 sky130_fd_pr__pfet_01v8 ad=0.1421 pd=1.56 as=0.1421 ps=1.56 w=0.49 l=0.2
X1000 VIN.t329 VIN.t328 OUT.t135 VIN.t37 sky130_fd_pr__pfet_01v8 ad=0.1421 pd=1.56 as=0.1421 ps=1.56 w=0.49 l=0.2
X1001 a_11352_2090# a_11152_310# VSS.t79 sky130_fd_pr__res_xhigh_po_0p69 l=6.9
X1002 OUT.t134 VIN.t326 VIN.t327 VIN.t34 sky130_fd_pr__pfet_01v8 ad=0.1421 pd=1.56 as=0.1421 ps=1.56 w=0.49 l=0.2
X1003 OUT.t133 VIN.t323 VIN.t325 VIN.t324 sky130_fd_pr__pfet_01v8 ad=0.1421 pd=1.56 as=0.1421 ps=1.56 w=0.49 l=0.2
X1004 OUT.t1031 bias-network_0.IBIAS1.t8 sky130_fd_pr__cap_mim_m3_1 l=6 w=6
X1005 VIN.t322 VIN.t321 OUT.t132 VIN.t130 sky130_fd_pr__pfet_01v8 ad=0.1421 pd=1.56 as=0.1421 ps=1.56 w=0.49 l=0.2
X1006 VIN.t320 VIN.t319 OUT.t131 VIN.t178 sky130_fd_pr__pfet_01v8 ad=0.1421 pd=1.56 as=0.1421 ps=1.56 w=0.49 l=0.2
X1007 OUT.t130 VIN.t317 VIN.t318 VIN.t278 sky130_fd_pr__pfet_01v8 ad=0.1421 pd=1.56 as=0.1421 ps=1.56 w=0.49 l=0.2
X1008 VIN.t316 VIN.t315 OUT.t129 VIN.t240 sky130_fd_pr__pfet_01v8 ad=0.1421 pd=1.56 as=0.1421 ps=1.56 w=0.49 l=0.2
X1009 VIN.t314 VIN.t312 OUT.t128 VIN.t313 sky130_fd_pr__pfet_01v8 ad=0.1421 pd=1.56 as=0.1421 ps=1.56 w=0.49 l=0.2
X1010 VIN.t311 VIN.t310 OUT.t127 VIN.t28 sky130_fd_pr__pfet_01v8 ad=0.1421 pd=1.56 as=0.1421 ps=1.56 w=0.49 l=0.2
X1011 VIN.t309 VIN.t308 OUT.t126 VIN.t10 sky130_fd_pr__pfet_01v8 ad=0.1421 pd=1.56 as=0.1421 ps=1.56 w=0.49 l=0.2
X1012 OUT.t125 VIN.t305 VIN.t307 VIN.t306 sky130_fd_pr__pfet_01v8 ad=0.1421 pd=1.56 as=0.1421 ps=1.56 w=0.49 l=0.2
X1013 VIN.t304 VIN.t303 OUT.t124 VIN.t63 sky130_fd_pr__pfet_01v8 ad=0.1421 pd=1.56 as=0.1421 ps=1.56 w=0.49 l=0.2
X1014 OUT.t123 VIN.t300 VIN.t302 VIN.t301 sky130_fd_pr__pfet_01v8 ad=0.1421 pd=1.56 as=0.1421 ps=1.56 w=0.49 l=0.2
X1015 VIN.t299 VIN.t298 OUT.t122 VIN.t66 sky130_fd_pr__pfet_01v8 ad=0.1421 pd=1.56 as=0.1421 ps=1.56 w=0.49 l=0.2
X1016 VIN.t297 VIN.t296 OUT.t121 VIN.t130 sky130_fd_pr__pfet_01v8 ad=0.1421 pd=1.56 as=0.1421 ps=1.56 w=0.49 l=0.2
X1017 VIN.t295 VIN.t294 OUT.t120 VIN.t92 sky130_fd_pr__pfet_01v8 ad=0.1421 pd=1.56 as=0.1421 ps=1.56 w=0.49 l=0.2
X1018 VIN.t293 VIN.t292 OUT.t119 VIN.t82 sky130_fd_pr__pfet_01v8 ad=0.1421 pd=1.56 as=0.1421 ps=1.56 w=0.49 l=0.2
X1019 OUT.t118 VIN.t290 VIN.t291 VIN.t7 sky130_fd_pr__pfet_01v8 ad=0.1421 pd=1.56 as=0.1421 ps=1.56 w=0.49 l=0.2
X1020 VIN.t289 VIN.t288 OUT.t117 VIN.t101 sky130_fd_pr__pfet_01v8 ad=0.1421 pd=1.56 as=0.1421 ps=1.56 w=0.49 l=0.2
X1021 VIN.t287 VIN.t286 OUT.t116 VIN.t49 sky130_fd_pr__pfet_01v8 ad=0.1421 pd=1.56 as=0.1421 ps=1.56 w=0.49 l=0.2
X1022 OUT.t115 VIN.t284 VIN.t285 VIN.t98 sky130_fd_pr__pfet_01v8 ad=0.1421 pd=1.56 as=0.1421 ps=1.56 w=0.49 l=0.2
X1023 VIN.t283 VIN.t282 OUT.t114 VIN.t75 sky130_fd_pr__pfet_01v8 ad=0.1421 pd=1.56 as=0.1421 ps=1.56 w=0.49 l=0.2
X1024 VIN.t281 VIN.t280 OUT.t113 VIN.t144 sky130_fd_pr__pfet_01v8 ad=0.1421 pd=1.56 as=0.1421 ps=1.56 w=0.49 l=0.2
X1025 a_3816_4748.t4 bias-network_0.IBIAS1.t34 a_3638_4130.t0 VIN.t2144 sky130_fd_pr__pfet_01v8 ad=1.015 pd=7.29 as=1.015 ps=7.29 w=7 l=0.6
X1026 OUT.t112 VIN.t277 VIN.t279 VIN.t278 sky130_fd_pr__pfet_01v8 ad=0.1421 pd=1.56 as=0.1421 ps=1.56 w=0.49 l=0.2
X1027 OUT.t111 VIN.t275 VIN.t276 VIN.t72 sky130_fd_pr__pfet_01v8 ad=0.1421 pd=1.56 as=0.1421 ps=1.56 w=0.49 l=0.2
X1028 OUT.t110 VIN.t273 VIN.t274 VIN.t98 sky130_fd_pr__pfet_01v8 ad=0.1421 pd=1.56 as=0.1421 ps=1.56 w=0.49 l=0.2
X1029 OUT.t109 VIN.t271 VIN.t272 VIN.t58 sky130_fd_pr__pfet_01v8 ad=0.1421 pd=1.56 as=0.1421 ps=1.56 w=0.49 l=0.2
X1030 OUT.t108 VIN.t268 VIN.t270 VIN.t269 sky130_fd_pr__pfet_01v8 ad=0.1421 pd=1.56 as=0.1421 ps=1.56 w=0.49 l=0.2
X1031 OUT.t107 VIN.t266 VIN.t267 VIN.t58 sky130_fd_pr__pfet_01v8 ad=0.1421 pd=1.56 as=0.1421 ps=1.56 w=0.49 l=0.2
X1032 OUT.t106 VIN.t264 VIN.t265 VIN.t119 sky130_fd_pr__pfet_01v8 ad=0.1421 pd=1.56 as=0.1421 ps=1.56 w=0.49 l=0.2
X1033 OUT.t105 VIN.t262 VIN.t263 VIN.t22 sky130_fd_pr__pfet_01v8 ad=0.1421 pd=1.56 as=0.1421 ps=1.56 w=0.49 l=0.2
X1034 OUT.t104 VIN.t260 VIN.t261 VIN.t7 sky130_fd_pr__pfet_01v8 ad=0.1421 pd=1.56 as=0.1421 ps=1.56 w=0.49 l=0.2
X1035 VIN.t259 VIN.t258 OUT.t103 VIN.t49 sky130_fd_pr__pfet_01v8 ad=0.1421 pd=1.56 as=0.1421 ps=1.56 w=0.49 l=0.2
X1036 OUT.t102 VIN.t256 VIN.t257 VIN.t52 sky130_fd_pr__pfet_01v8 ad=0.1421 pd=1.56 as=0.1421 ps=1.56 w=0.49 l=0.2
X1037 a_3816_4748.t10 bias-network_0.VREF.t39 VIN.t2137 VIN.t2136 sky130_fd_pr__pfet_01v8 ad=1.015 pd=7.29 as=1.015 ps=7.29 w=7 l=0.6
X1038 VIN.t255 VIN.t254 OUT.t101 VIN.t135 sky130_fd_pr__pfet_01v8 ad=0.1421 pd=1.56 as=0.1421 ps=1.56 w=0.49 l=0.2
X1039 VIN.t253 VIN.t252 OUT.t100 VIN.t144 sky130_fd_pr__pfet_01v8 ad=0.1421 pd=1.56 as=0.1421 ps=1.56 w=0.49 l=0.2
X1040 OUT.t99 VIN.t250 VIN.t251 VIN.t34 sky130_fd_pr__pfet_01v8 ad=0.1421 pd=1.56 as=0.1421 ps=1.56 w=0.49 l=0.2
X1041 OUT.t98 VIN.t248 VIN.t249 VIN.t16 sky130_fd_pr__pfet_01v8 ad=0.1421 pd=1.56 as=0.1421 ps=1.56 w=0.49 l=0.2
X1042 OUT.t97 VIN.t246 VIN.t247 VIN.t13 sky130_fd_pr__pfet_01v8 ad=0.1421 pd=1.56 as=0.1421 ps=1.56 w=0.49 l=0.2
X1043 VIN.t245 VIN.t244 OUT.t96 VIN.t25 sky130_fd_pr__pfet_01v8 ad=0.1421 pd=1.56 as=0.1421 ps=1.56 w=0.49 l=0.2
X1044 VIN.t2151 bias-network_0.IBIAS1.t35 a_3816_4748.t0 VIN.t2132 sky130_fd_pr__pfet_01v8 ad=0.23925 pd=1.94 as=0.23925 ps=1.94 w=1.65 l=0.6
X1045 VIN.t243 VIN.t242 OUT.t95 VIN.t95 sky130_fd_pr__pfet_01v8 ad=0.1421 pd=1.56 as=0.1421 ps=1.56 w=0.49 l=0.2
X1046 VIN.t241 VIN.t239 OUT.t94 VIN.t240 sky130_fd_pr__pfet_01v8 ad=0.1421 pd=1.56 as=0.1421 ps=1.56 w=0.49 l=0.2
X1047 OUT.t93 VIN.t237 VIN.t238 VIN.t22 sky130_fd_pr__pfet_01v8 ad=0.1421 pd=1.56 as=0.1421 ps=1.56 w=0.49 l=0.2
X1048 VIN.t236 VIN.t235 OUT.t92 VIN.t190 sky130_fd_pr__pfet_01v8 ad=0.1421 pd=1.56 as=0.1421 ps=1.56 w=0.49 l=0.2
X1049 VIN.t234 VIN.t232 OUT.t91 VIN.t233 sky130_fd_pr__pfet_01v8 ad=0.1421 pd=1.56 as=0.1421 ps=1.56 w=0.49 l=0.2
X1050 OUT.t90 VIN.t230 VIN.t231 VIN.t1 sky130_fd_pr__pfet_01v8 ad=0.1421 pd=1.56 as=0.1421 ps=1.56 w=0.49 l=0.2
X1051 VIN.t229 VIN.t227 OUT.t89 VIN.t228 sky130_fd_pr__pfet_01v8 ad=0.1421 pd=1.56 as=0.1421 ps=1.56 w=0.49 l=0.2
X1052 OUT.t88 VIN.t225 VIN.t226 VIN.t4 sky130_fd_pr__pfet_01v8 ad=0.1421 pd=1.56 as=0.1421 ps=1.56 w=0.49 l=0.2
X1053 VIN.t224 VIN.t223 OUT.t87 VIN.t211 sky130_fd_pr__pfet_01v8 ad=0.1421 pd=1.56 as=0.1421 ps=1.56 w=0.49 l=0.2
X1054 OUT.t86 VIN.t221 VIN.t222 VIN.t19 sky130_fd_pr__pfet_01v8 ad=0.1421 pd=1.56 as=0.1421 ps=1.56 w=0.49 l=0.2
X1055 VIN.t220 VIN.t219 OUT.t85 VIN.t40 sky130_fd_pr__pfet_01v8 ad=0.1421 pd=1.56 as=0.1421 ps=1.56 w=0.49 l=0.2
X1056 OUT.t84 VIN.t217 VIN.t218 VIN.t31 sky130_fd_pr__pfet_01v8 ad=0.1421 pd=1.56 as=0.1421 ps=1.56 w=0.49 l=0.2
X1057 VIN.t216 VIN.t215 OUT.t83 VIN.t46 sky130_fd_pr__pfet_01v8 ad=0.1421 pd=1.56 as=0.1421 ps=1.56 w=0.49 l=0.2
X1058 OUT.t82 VIN.t213 VIN.t214 VIN.t22 sky130_fd_pr__pfet_01v8 ad=0.1421 pd=1.56 as=0.1421 ps=1.56 w=0.49 l=0.2
X1059 VIN.t212 VIN.t210 OUT.t81 VIN.t211 sky130_fd_pr__pfet_01v8 ad=0.1421 pd=1.56 as=0.1421 ps=1.56 w=0.49 l=0.2
X1060 a_10552_2090# a_10752_310# VSS.t80 sky130_fd_pr__res_xhigh_po_0p69 l=6.9
X1061 VIN.t209 VIN.t208 OUT.t80 VIN.t55 sky130_fd_pr__pfet_01v8 ad=0.1421 pd=1.56 as=0.1421 ps=1.56 w=0.49 l=0.2
X1062 OUT.t79 VIN.t206 VIN.t207 VIN.t4 sky130_fd_pr__pfet_01v8 ad=0.1421 pd=1.56 as=0.1421 ps=1.56 w=0.49 l=0.2
X1063 OUT.t78 VIN.t204 VIN.t205 VIN.t31 sky130_fd_pr__pfet_01v8 ad=0.1421 pd=1.56 as=0.1421 ps=1.56 w=0.49 l=0.2
X1064 a_638_4130.t5 a_638_4130.t4 VSS.t102 VSS.t101 sky130_fd_pr__nfet_01v8 ad=0.3045 pd=2.68 as=0.15225 ps=1.34 w=1.05 l=0.6
X1065 VIN.t203 VIN.t202 OUT.t77 VIN.t190 sky130_fd_pr__pfet_01v8 ad=0.1421 pd=1.56 as=0.1421 ps=1.56 w=0.49 l=0.2
X1066 VIN.t201 VIN.t200 OUT.t76 VIN.t111 sky130_fd_pr__pfet_01v8 ad=0.1421 pd=1.56 as=0.1421 ps=1.56 w=0.49 l=0.2
X1067 OUT.t75 VIN.t198 VIN.t199 VIN.t164 sky130_fd_pr__pfet_01v8 ad=0.1421 pd=1.56 as=0.1421 ps=1.56 w=0.49 l=0.2
X1068 OUT.t74 VIN.t196 VIN.t197 VIN.t158 sky130_fd_pr__pfet_01v8 ad=0.1421 pd=1.56 as=0.1421 ps=1.56 w=0.49 l=0.2
X1069 VIN.t195 VIN.t194 OUT.t73 VIN.t46 sky130_fd_pr__pfet_01v8 ad=0.1421 pd=1.56 as=0.1421 ps=1.56 w=0.49 l=0.2
X1070 VIN.t193 VIN.t192 OUT.t72 VIN.t25 sky130_fd_pr__pfet_01v8 ad=0.1421 pd=1.56 as=0.1421 ps=1.56 w=0.49 l=0.2
X1071 VIN.t191 VIN.t189 OUT.t71 VIN.t190 sky130_fd_pr__pfet_01v8 ad=0.1421 pd=1.56 as=0.1421 ps=1.56 w=0.49 l=0.2
X1072 OUT.t70 VIN.t187 VIN.t188 VIN.t19 sky130_fd_pr__pfet_01v8 ad=0.1421 pd=1.56 as=0.1421 ps=1.56 w=0.49 l=0.2
X1073 OUT.t69 VIN.t184 VIN.t186 VIN.t185 sky130_fd_pr__pfet_01v8 ad=0.1421 pd=1.56 as=0.1421 ps=1.56 w=0.49 l=0.2
X1074 OUT.t68 VIN.t182 VIN.t183 VIN.t155 sky130_fd_pr__pfet_01v8 ad=0.1421 pd=1.56 as=0.1421 ps=1.56 w=0.49 l=0.2
X1075 VIN.t181 VIN.t180 OUT.t67 VIN.t63 sky130_fd_pr__pfet_01v8 ad=0.1421 pd=1.56 as=0.1421 ps=1.56 w=0.49 l=0.2
X1076 VIN.t179 VIN.t177 OUT.t66 VIN.t178 sky130_fd_pr__pfet_01v8 ad=0.1421 pd=1.56 as=0.1421 ps=1.56 w=0.49 l=0.2
X1077 OUT.t65 VIN.t175 VIN.t176 VIN.t87 sky130_fd_pr__pfet_01v8 ad=0.1421 pd=1.56 as=0.1421 ps=1.56 w=0.49 l=0.2
X1078 OUT.t64 VIN.t173 VIN.t174 VIN.t1 sky130_fd_pr__pfet_01v8 ad=0.1421 pd=1.56 as=0.1421 ps=1.56 w=0.49 l=0.2
X1079 OUT.t63 VIN.t171 VIN.t172 VIN.t141 sky130_fd_pr__pfet_01v8 ad=0.1421 pd=1.56 as=0.1421 ps=1.56 w=0.49 l=0.2
X1080 VIN.t2139 bias-network_0.VREF.t40 a_3816_4748.t11 VIN.t2138 sky130_fd_pr__pfet_01v8 ad=1.015 pd=7.29 as=1.015 ps=7.29 w=7 l=0.6
X1081 OUT.t62 VIN.t169 VIN.t170 VIN.t167 sky130_fd_pr__pfet_01v8 ad=0.1421 pd=1.56 as=0.1421 ps=1.56 w=0.49 l=0.2
X1082 OUT.t61 VIN.t166 VIN.t168 VIN.t167 sky130_fd_pr__pfet_01v8 ad=0.1421 pd=1.56 as=0.1421 ps=1.56 w=0.49 l=0.2
X1083 OUT.t60 VIN.t163 VIN.t165 VIN.t164 sky130_fd_pr__pfet_01v8 ad=0.1421 pd=1.56 as=0.1421 ps=1.56 w=0.49 l=0.2
X1084 VIN.t162 VIN.t160 OUT.t59 VIN.t161 sky130_fd_pr__pfet_01v8 ad=0.1421 pd=1.56 as=0.1421 ps=1.56 w=0.49 l=0.2
X1085 OUT.t58 VIN.t157 VIN.t159 VIN.t158 sky130_fd_pr__pfet_01v8 ad=0.1421 pd=1.56 as=0.1421 ps=1.56 w=0.49 l=0.2
X1086 OUT.t57 VIN.t154 VIN.t156 VIN.t155 sky130_fd_pr__pfet_01v8 ad=0.1421 pd=1.56 as=0.1421 ps=1.56 w=0.49 l=0.2
X1087 OUT.t56 VIN.t152 VIN.t153 VIN.t52 sky130_fd_pr__pfet_01v8 ad=0.1421 pd=1.56 as=0.1421 ps=1.56 w=0.49 l=0.2
X1088 VSS.t1 a_3638_4130.t4 a_3638_4130.t5 VSS.t0 sky130_fd_pr__nfet_01v8 ad=0.15225 pd=1.34 as=0.3045 ps=2.68 w=1.05 l=0.6
X1089 OUT.t55 VIN.t150 VIN.t151 VIN.t98 sky130_fd_pr__pfet_01v8 ad=0.1421 pd=1.56 as=0.1421 ps=1.56 w=0.49 l=0.2
X1090 VIN.t149 VIN.t148 OUT.t54 VIN.t101 sky130_fd_pr__pfet_01v8 ad=0.1421 pd=1.56 as=0.1421 ps=1.56 w=0.49 l=0.2
X1091 OUT.t53 VIN.t146 VIN.t147 VIN.t119 sky130_fd_pr__pfet_01v8 ad=0.1421 pd=1.56 as=0.1421 ps=1.56 w=0.49 l=0.2
X1092 VSS.t82 VSS.t83 VSS.t81 sky130_fd_pr__res_xhigh_po_0p69 l=6.9
X1093 a_816_4748.t4 error-amplifier_0.VN a_638_4130.t0 VIN.t2112 sky130_fd_pr__pfet_01v8 ad=1.015 pd=7.29 as=2.03 ps=14.58 w=7 l=0.6
X1094 VIN.t145 VIN.t143 OUT.t52 VIN.t144 sky130_fd_pr__pfet_01v8 ad=0.1421 pd=1.56 as=0.1421 ps=1.56 w=0.49 l=0.2
X1095 OUT.t51 VIN.t140 VIN.t142 VIN.t141 sky130_fd_pr__pfet_01v8 ad=0.1421 pd=1.56 as=0.1421 ps=1.56 w=0.49 l=0.2
X1096 OUT.t50 VIN.t137 VIN.t139 VIN.t138 sky130_fd_pr__pfet_01v8 ad=0.1421 pd=1.56 as=0.1421 ps=1.56 w=0.49 l=0.2
X1097 VIN.t136 VIN.t134 OUT.t49 VIN.t135 sky130_fd_pr__pfet_01v8 ad=0.1421 pd=1.56 as=0.1421 ps=1.56 w=0.49 l=0.2
X1098 OUT.t48 VIN.t132 VIN.t133 VIN.t34 sky130_fd_pr__pfet_01v8 ad=0.1421 pd=1.56 as=0.1421 ps=1.56 w=0.49 l=0.2
X1099 VIN.t131 VIN.t129 OUT.t47 VIN.t130 sky130_fd_pr__pfet_01v8 ad=0.1421 pd=1.56 as=0.1421 ps=1.56 w=0.49 l=0.2
X1100 VIN.t128 VIN.t126 OUT.t46 VIN.t127 sky130_fd_pr__pfet_01v8 ad=0.1421 pd=1.56 as=0.1421 ps=1.56 w=0.49 l=0.2
X1101 VIN.t125 VIN.t123 OUT.t45 VIN.t124 sky130_fd_pr__pfet_01v8 ad=0.1421 pd=1.56 as=0.1421 ps=1.56 w=0.49 l=0.2
X1102 VIN.t122 VIN.t121 OUT.t44 VIN.t116 sky130_fd_pr__pfet_01v8 ad=0.1421 pd=1.56 as=0.1421 ps=1.56 w=0.49 l=0.2
X1103 OUT.t43 VIN.t118 VIN.t120 VIN.t119 sky130_fd_pr__pfet_01v8 ad=0.1421 pd=1.56 as=0.1421 ps=1.56 w=0.49 l=0.2
X1104 VIN.t117 VIN.t115 OUT.t42 VIN.t116 sky130_fd_pr__pfet_01v8 ad=0.1421 pd=1.56 as=0.1421 ps=1.56 w=0.49 l=0.2
X1105 OUT.t41 VIN.t113 VIN.t114 VIN.t108 sky130_fd_pr__pfet_01v8 ad=0.1421 pd=1.56 as=0.1421 ps=1.56 w=0.49 l=0.2
X1106 VIN.t112 VIN.t110 OUT.t40 VIN.t111 sky130_fd_pr__pfet_01v8 ad=0.1421 pd=1.56 as=0.1421 ps=1.56 w=0.49 l=0.2
X1107 OUT.t39 VIN.t107 VIN.t109 VIN.t108 sky130_fd_pr__pfet_01v8 ad=0.1421 pd=1.56 as=0.1421 ps=1.56 w=0.49 l=0.2
X1108 VIN.t106 VIN.t105 OUT.t38 VIN.t63 sky130_fd_pr__pfet_01v8 ad=0.1421 pd=1.56 as=0.1421 ps=1.56 w=0.49 l=0.2
X1109 VIN.t104 VIN.t103 OUT.t37 VIN.t66 sky130_fd_pr__pfet_01v8 ad=0.1421 pd=1.56 as=0.1421 ps=1.56 w=0.49 l=0.2
X1110 VIN.t102 VIN.t100 OUT.t36 VIN.t101 sky130_fd_pr__pfet_01v8 ad=0.1421 pd=1.56 as=0.1421 ps=1.56 w=0.49 l=0.2
X1111 OUT.t35 VIN.t97 VIN.t99 VIN.t98 sky130_fd_pr__pfet_01v8 ad=0.1421 pd=1.56 as=0.1421 ps=1.56 w=0.49 l=0.2
X1112 VIN.t96 VIN.t94 OUT.t34 VIN.t95 sky130_fd_pr__pfet_01v8 ad=0.1421 pd=1.56 as=0.1421 ps=1.56 w=0.49 l=0.2
X1113 VIN.t93 VIN.t91 OUT.t33 VIN.t92 sky130_fd_pr__pfet_01v8 ad=0.1421 pd=1.56 as=0.1421 ps=1.56 w=0.49 l=0.2
X1114 OUT.t32 VIN.t89 VIN.t90 VIN.t16 sky130_fd_pr__pfet_01v8 ad=0.1421 pd=1.56 as=0.1421 ps=1.56 w=0.49 l=0.2
X1115 OUT.t31 VIN.t86 VIN.t88 VIN.t87 sky130_fd_pr__pfet_01v8 ad=0.1421 pd=1.56 as=0.1421 ps=1.56 w=0.49 l=0.2
X1116 OUT.t30 VIN.t84 VIN.t85 VIN.t13 sky130_fd_pr__pfet_01v8 ad=0.1421 pd=1.56 as=0.1421 ps=1.56 w=0.49 l=0.2
X1117 VIN.t83 VIN.t81 OUT.t29 VIN.t82 sky130_fd_pr__pfet_01v8 ad=0.1421 pd=1.56 as=0.1421 ps=1.56 w=0.49 l=0.2
X1118 VIN.t80 VIN.t79 OUT.t28 VIN.t40 sky130_fd_pr__pfet_01v8 ad=0.1421 pd=1.56 as=0.1421 ps=1.56 w=0.49 l=0.2
X1119 OUT.t27 VIN.t77 VIN.t78 VIN.t31 sky130_fd_pr__pfet_01v8 ad=0.1421 pd=1.56 as=0.1421 ps=1.56 w=0.49 l=0.2
X1120 VIN.t76 VIN.t74 OUT.t26 VIN.t75 sky130_fd_pr__pfet_01v8 ad=0.1421 pd=1.56 as=0.1421 ps=1.56 w=0.49 l=0.2
X1121 OUT.t25 VIN.t71 VIN.t73 VIN.t72 sky130_fd_pr__pfet_01v8 ad=0.1421 pd=1.56 as=0.1421 ps=1.56 w=0.49 l=0.2
X1122 OUT.t24 VIN.t68 VIN.t70 VIN.t69 sky130_fd_pr__pfet_01v8 ad=0.1421 pd=1.56 as=0.1421 ps=1.56 w=0.49 l=0.2
X1123 VIN.t67 VIN.t65 OUT.t23 VIN.t66 sky130_fd_pr__pfet_01v8 ad=0.1421 pd=1.56 as=0.1421 ps=1.56 w=0.49 l=0.2
X1124 VIN.t64 VIN.t62 OUT.t22 VIN.t63 sky130_fd_pr__pfet_01v8 ad=0.1421 pd=1.56 as=0.1421 ps=1.56 w=0.49 l=0.2
X1125 OUT.t21 VIN.t60 VIN.t61 VIN.t58 sky130_fd_pr__pfet_01v8 ad=0.1421 pd=1.56 as=0.1421 ps=1.56 w=0.49 l=0.2
X1126 OUT.t20 VIN.t57 VIN.t59 VIN.t58 sky130_fd_pr__pfet_01v8 ad=0.1421 pd=1.56 as=0.1421 ps=1.56 w=0.49 l=0.2
X1127 VIN.t56 VIN.t54 OUT.t19 VIN.t55 sky130_fd_pr__pfet_01v8 ad=0.1421 pd=1.56 as=0.1421 ps=1.56 w=0.49 l=0.2
X1128 OUT.t18 VIN.t51 VIN.t53 VIN.t52 sky130_fd_pr__pfet_01v8 ad=0.1421 pd=1.56 as=0.1421 ps=1.56 w=0.49 l=0.2
X1129 VIN.t50 VIN.t48 OUT.t17 VIN.t49 sky130_fd_pr__pfet_01v8 ad=0.1421 pd=1.56 as=0.1421 ps=1.56 w=0.49 l=0.2
X1130 a_8952_2090# a_9152_310# VSS.t84 sky130_fd_pr__res_xhigh_po_0p69 l=6.9
X1131 VIN.t47 VIN.t45 OUT.t16 VIN.t46 sky130_fd_pr__pfet_01v8 ad=0.1421 pd=1.56 as=0.1421 ps=1.56 w=0.49 l=0.2
X1132 OUT.t15 VIN.t42 VIN.t44 VIN.t43 sky130_fd_pr__pfet_01v8 ad=0.1421 pd=1.56 as=0.1421 ps=1.56 w=0.49 l=0.2
X1133 VIN.t41 VIN.t39 OUT.t14 VIN.t40 sky130_fd_pr__pfet_01v8 ad=0.1421 pd=1.56 as=0.1421 ps=1.56 w=0.49 l=0.2
X1134 OUT.t1032 VIN.t2155 sky130_fd_pr__cap_mim_m3_1 l=6 w=6
X1135 VIN.t38 VIN.t36 OUT.t13 VIN.t37 sky130_fd_pr__pfet_01v8 ad=0.1421 pd=1.56 as=0.1421 ps=1.56 w=0.49 l=0.2
X1136 OUT.t12 VIN.t33 VIN.t35 VIN.t34 sky130_fd_pr__pfet_01v8 ad=0.1421 pd=1.56 as=0.1421 ps=1.56 w=0.49 l=0.2
X1137 OUT.t11 VIN.t30 VIN.t32 VIN.t31 sky130_fd_pr__pfet_01v8 ad=0.1421 pd=1.56 as=0.1421 ps=1.56 w=0.49 l=0.2
X1138 VIN.t29 VIN.t27 OUT.t10 VIN.t28 sky130_fd_pr__pfet_01v8 ad=0.1421 pd=1.56 as=0.1421 ps=1.56 w=0.49 l=0.2
X1139 VIN.t26 VIN.t24 OUT.t9 VIN.t25 sky130_fd_pr__pfet_01v8 ad=0.1421 pd=1.56 as=0.1421 ps=1.56 w=0.49 l=0.2
X1140 OUT.t8 VIN.t21 VIN.t23 VIN.t22 sky130_fd_pr__pfet_01v8 ad=0.1421 pd=1.56 as=0.1421 ps=1.56 w=0.49 l=0.2
X1141 OUT.t7 VIN.t18 VIN.t20 VIN.t19 sky130_fd_pr__pfet_01v8 ad=0.1421 pd=1.56 as=0.1421 ps=1.56 w=0.49 l=0.2
X1142 OUT.t6 VIN.t15 VIN.t17 VIN.t16 sky130_fd_pr__pfet_01v8 ad=0.1421 pd=1.56 as=0.1421 ps=1.56 w=0.49 l=0.2
X1143 OUT.t5 VIN.t12 VIN.t14 VIN.t13 sky130_fd_pr__pfet_01v8 ad=0.1421 pd=1.56 as=0.1421 ps=1.56 w=0.49 l=0.2
X1144 VIN.t11 VIN.t9 OUT.t4 VIN.t10 sky130_fd_pr__pfet_01v8 ad=0.1421 pd=1.56 as=0.1421 ps=1.56 w=0.49 l=0.2
X1145 OUT.t3 VIN.t6 VIN.t8 VIN.t7 sky130_fd_pr__pfet_01v8 ad=0.1421 pd=1.56 as=0.1421 ps=1.56 w=0.49 l=0.2
X1146 OUT.t2 VIN.t3 VIN.t5 VIN.t4 sky130_fd_pr__pfet_01v8 ad=0.1421 pd=1.56 as=0.1421 ps=1.56 w=0.49 l=0.2
X1147 OUT.t1 VIN.t0 VIN.t2 VIN.t1 sky130_fd_pr__pfet_01v8 ad=0.1421 pd=1.56 as=0.1421 ps=1.56 w=0.49 l=0.2
R0 VIN.n1535 VIN.n65 5788.23
R1 VIN.n1535 VIN.n66 5788.23
R2 VIN.n1539 VIN.n65 5788.23
R3 VIN.n1539 VIN.n66 5788.23
R4 VIN.n1330 VIN.n1320 5788.23
R5 VIN.n1320 VIN.n1318 5788.23
R6 VIN.n1330 VIN.n1322 5788.23
R7 VIN.n1322 VIN.n1318 5788.23
R8 VIN.n1533 VIN.n63 3900
R9 VIN.n1541 VIN.n63 3900
R10 VIN.n1533 VIN.n64 3900
R11 VIN.n1541 VIN.n64 3900
R12 VIN.n1332 VIN.n1315 3900
R13 VIN.n1332 VIN.n1316 3900
R14 VIN.n1317 VIN.n1315 3900
R15 VIN.n1317 VIN.n1316 3900
R16 VIN.n15 VIN.t1133 652.596
R17 VIN.n15 VIN.t1085 652.596
R18 VIN.n14 VIN.t1663 652.596
R19 VIN.n14 VIN.t1615 652.596
R20 VIN.n13 VIN.t675 652.596
R21 VIN.n13 VIN.t627 652.596
R22 VIN.n12 VIN.t402 652.596
R23 VIN.n12 VIN.t350 652.596
R24 VIN.n11 VIN.t955 652.596
R25 VIN.n11 VIN.t913 652.596
R26 VIN.n10 VIN.t565 652.596
R27 VIN.n10 VIN.t519 652.596
R28 VIN.n9 VIN.t1703 652.596
R29 VIN.n9 VIN.t1653 652.596
R30 VIN.n8 VIN.t201 652.596
R31 VIN.n8 VIN.t153 652.596
R32 VIN.n7 VIN.t1869 652.596
R33 VIN.n7 VIN.t1821 652.596
R34 VIN.n6 VIN.t707 652.596
R35 VIN.n6 VIN.t53 652.596
R36 VIN.n5 VIN.t1865 652.596
R37 VIN.n5 VIN.t1277 652.596
R38 VIN.n4 VIN.t879 652.596
R39 VIN.n4 VIN.t257 652.596
R40 VIN.n3 VIN.t2017 652.596
R41 VIN.n3 VIN.t1413 652.596
R42 VIN.n2 VIN.t1155 652.596
R43 VIN.n2 VIN.t551 652.596
R44 VIN.n1 VIN.t112 652.596
R45 VIN.n1 VIN.t1571 652.596
R46 VIN.n0 VIN.t1899 652.596
R47 VIN.n0 VIN.t1313 652.596
R48 VIN.n35 VIN.t1039 652.596
R49 VIN.n35 VIN.t961 652.596
R50 VIN.n34 VIN.t1567 652.596
R51 VIN.n34 VIN.t1489 652.596
R52 VIN.n33 VIN.t589 652.596
R53 VIN.n33 VIN.t521 652.596
R54 VIN.n32 VIN.t293 652.596
R55 VIN.n32 VIN.t207 652.596
R56 VIN.n31 VIN.t859 652.596
R57 VIN.n31 VIN.t781 652.596
R58 VIN.n30 VIN.t475 652.596
R59 VIN.n30 VIN.t400 652.596
R60 VIN.n29 VIN.t1603 652.596
R61 VIN.n29 VIN.t1521 652.596
R62 VIN.n28 VIN.t83 652.596
R63 VIN.n28 VIN.t2103 652.596
R64 VIN.n27 VIN.t1769 652.596
R65 VIN.n27 VIN.t1697 652.596
R66 VIN.n26 VIN.t1525 652.596
R67 VIN.n26 VIN.t809 652.596
R68 VIN.n25 VIN.t661 652.596
R69 VIN.n25 VIN.t1967 652.596
R70 VIN.n24 VIN.t1695 652.596
R71 VIN.n24 VIN.t981 652.596
R72 VIN.n23 VIN.t813 652.596
R73 VIN.n23 VIN.t5 652.596
R74 VIN.n22 VIN.t1973 652.596
R75 VIN.n22 VIN.t1245 652.596
R76 VIN.n21 VIN.t989 652.596
R77 VIN.n21 VIN.t226 652.596
R78 VIN.n20 VIN.t685 652.596
R79 VIN.n20 VIN.t1987 652.596
R80 VIN.n1455 VIN.t457 652.596
R81 VIN.n1455 VIN.t503 652.596
R82 VIN.n1454 VIN.t1007 652.596
R83 VIN.n1454 VIN.t1059 652.596
R84 VIN.n1453 VIN.t2043 652.596
R85 VIN.n1453 VIN.t2097 652.596
R86 VIN.n1452 VIN.t1739 652.596
R87 VIN.n1452 VIN.t1789 652.596
R88 VIN.n1451 VIN.t255 652.596
R89 VIN.n1451 VIN.t307 652.596
R90 VIN.n1450 VIN.t1923 652.596
R91 VIN.n1450 VIN.t1963 652.596
R92 VIN.n1449 VIN.t1033 652.596
R93 VIN.n1449 VIN.t1081 652.596
R94 VIN.n1448 VIN.t1565 652.596
R95 VIN.n1448 VIN.t1613 652.596
R96 VIN.n1447 VIN.t1199 652.596
R97 VIN.n1447 VIN.t1243 652.596
R98 VIN.n1446 VIN.t2037 652.596
R99 VIN.n1446 VIN.t609 652.596
R100 VIN.n1445 VIN.t1171 652.596
R101 VIN.n1445 VIN.t1755 652.596
R102 VIN.n1444 VIN.t136 652.596
R103 VIN.n1444 VIN.t771 652.596
R104 VIN.n1443 VIN.t1319 652.596
R105 VIN.n1443 VIN.t1911 652.596
R106 VIN.n1442 VIN.t449 652.596
R107 VIN.n1442 VIN.t1043 652.596
R108 VIN.n1441 VIN.t1461 652.596
R109 VIN.n1441 VIN.t2073 652.596
R110 VIN.n1440 VIN.t1193 652.596
R111 VIN.n1440 VIN.t1779 652.596
R112 VIN.n38 VIN.t1737 652.596
R113 VIN.n38 VIN.t1785 652.596
R114 VIN.n43 VIN.t253 652.596
R115 VIN.n43 VIN.t302 652.596
R116 VIN.n44 VIN.t1323 652.596
R117 VIN.n44 VIN.t1371 652.596
R118 VIN.n45 VIN.t1029 652.596
R119 VIN.n45 VIN.t1075 652.596
R120 VIN.n46 VIN.t1561 652.596
R121 VIN.n46 VIN.t1611 652.596
R122 VIN.n47 VIN.t1197 652.596
R123 VIN.n47 VIN.t1241 652.596
R124 VIN.n48 VIN.t281 652.596
R125 VIN.n48 VIN.t344 652.596
R126 VIN.n49 VIN.t845 652.596
R127 VIN.n49 VIN.t907 652.596
R128 VIN.n50 VIN.t473 652.596
R129 VIN.n50 VIN.t517 652.596
R130 VIN.n51 VIN.t729 652.596
R131 VIN.n51 VIN.t1351 652.596
R132 VIN.n52 VIN.t1887 652.596
R133 VIN.n52 VIN.t471 652.596
R134 VIN.n53 VIN.t905 652.596
R135 VIN.n53 VIN.t1487 652.596
R136 VIN.n54 VIN.t2041 652.596
R137 VIN.n54 VIN.t613 652.596
R138 VIN.n55 VIN.t1179 652.596
R139 VIN.n55 VIN.t1759 652.596
R140 VIN.n56 VIN.t145 652.596
R141 VIN.n56 VIN.t775 652.596
R142 VIN.n57 VIN.t1919 652.596
R143 VIN.n57 VIN.t495 652.596
R144 VIN.n1479 VIN.t283 652.596
R145 VIN.n1479 VIN.t1099 652.596
R146 VIN.n1478 VIN.t847 652.596
R147 VIN.n1478 VIN.t1633 652.596
R148 VIN.n1477 VIN.t1895 652.596
R149 VIN.n1477 VIN.t643 652.596
R150 VIN.n1476 VIN.t1599 652.596
R151 VIN.n1476 VIN.t356 652.596
R152 VIN.n1475 VIN.t76 652.596
R153 VIN.n1475 VIN.t921 652.596
R154 VIN.n1474 VIN.t1767 652.596
R155 VIN.n1474 VIN.t535 652.596
R156 VIN.n1473 VIN.t885 652.596
R157 VIN.n1473 VIN.t1657 652.596
R158 VIN.n1472 VIN.t1435 652.596
R159 VIN.n1472 VIN.t168 652.596
R160 VIN.n1471 VIN.t1061 652.596
R161 VIN.n1471 VIN.t1827 652.596
R162 VIN.n1470 VIN.t1517 652.596
R163 VIN.n1470 VIN.t925 652.596
R164 VIN.n1469 VIN.t655 652.596
R165 VIN.n1469 VIN.t2077 652.596
R166 VIN.n1468 VIN.t1687 652.596
R167 VIN.n1468 VIN.t1093 652.596
R168 VIN.n1467 VIN.t801 652.596
R169 VIN.n1467 VIN.t170 652.596
R170 VIN.n1466 VIN.t1959 652.596
R171 VIN.n1466 VIN.t1357 652.596
R172 VIN.n1465 VIN.t975 652.596
R173 VIN.n1465 VIN.t352 652.596
R174 VIN.n1464 VIN.t679 652.596
R175 VIN.n1464 VIN.t2109 652.596
R176 VIN.n95 VIN.t179 652.596
R177 VIN.n95 VIN.t231 652.596
R178 VIN.n94 VIN.t755 652.596
R179 VIN.n94 VIN.t799 652.596
R180 VIN.n93 VIN.t1791 652.596
R181 VIN.n93 VIN.t1841 652.596
R182 VIN.n92 VIN.t1493 652.596
R183 VIN.n92 VIN.t1543 652.596
R184 VIN.n91 VIN.t2065 652.596
R185 VIN.n91 VIN.t2111 652.596
R186 VIN.n90 VIN.t1673 652.596
R187 VIN.n90 VIN.t1715 652.596
R188 VIN.n89 VIN.t783 652.596
R189 VIN.n89 VIN.t831 652.596
R190 VIN.n88 VIN.t1353 652.596
R191 VIN.n88 VIN.t1395 652.596
R192 VIN.n87 VIN.t953 652.596
R193 VIN.n87 VIN.t1009 652.596
R194 VIN.n86 VIN.t320 652.596
R195 VIN.n86 VIN.t939 652.596
R196 VIN.n85 VIN.t1475 652.596
R197 VIN.n85 VIN.t2095 652.596
R198 VIN.n84 VIN.t497 652.596
R199 VIN.n84 VIN.t1105 652.596
R200 VIN.n83 VIN.t1617 652.596
R201 VIN.n83 VIN.t174 652.596
R202 VIN.n82 VIN.t751 652.596
R203 VIN.n82 VIN.t1373 652.596
R204 VIN.n81 VIN.t1787 652.596
R205 VIN.n81 VIN.t365 652.596
R206 VIN.n80 VIN.t1491 652.596
R207 VIN.n80 VIN.t2 652.596
R208 VIN.n1500 VIN.t50 652.596
R209 VIN.n1500 VIN.t114 652.596
R210 VIN.n1501 VIN.t663 652.596
R211 VIN.n1501 VIN.t705 652.596
R212 VIN.n1502 VIN.t1699 652.596
R213 VIN.n1502 VIN.t1741 652.596
R214 VIN.n1503 VIN.t1415 652.596
R215 VIN.n1503 VIN.t1453 652.596
R216 VIN.n1504 VIN.t1971 652.596
R217 VIN.n1504 VIN.t2015 652.596
R218 VIN.n1505 VIN.t1573 652.596
R219 VIN.n1505 VIN.t1623 652.596
R220 VIN.n1506 VIN.t681 652.596
R221 VIN.n1506 VIN.t735 652.596
R222 VIN.n1507 VIN.t1255 652.596
R223 VIN.n1507 VIN.t1309 652.596
R224 VIN.n1508 VIN.t855 652.596
R225 VIN.n1508 VIN.t909 652.596
R226 VIN.n1509 VIN.t1161 652.596
R227 VIN.n1509 VIN.t1747 652.596
R228 VIN.n1510 VIN.t259 652.596
R229 VIN.n1510 VIN.t881 652.596
R230 VIN.n1511 VIN.t1329 652.596
R231 VIN.n1511 VIN.t1921 652.596
R232 VIN.n1512 VIN.t437 652.596
R233 VIN.n1512 VIN.t1031 652.596
R234 VIN.n1513 VIN.t1569 652.596
R235 VIN.n1513 VIN.t109 652.596
R236 VIN.n1514 VIN.t591 652.596
R237 VIN.n1514 VIN.t1201 652.596
R238 VIN.n1515 VIN.t287 652.596
R239 VIN.n1515 VIN.t915 652.596
R240 VIN.n1562 VIN.t1165 652.596
R241 VIN.n1562 VIN.t1211 652.596
R242 VIN.n1561 VIN.t1701 652.596
R243 VIN.n1561 VIN.t1743 652.596
R244 VIN.n1560 VIN.t711 652.596
R245 VIN.n1560 VIN.t761 652.596
R246 VIN.n1559 VIN.t447 652.596
R247 VIN.n1559 VIN.t485 652.596
R248 VIN.n1558 VIN.t991 652.596
R249 VIN.n1558 VIN.t1035 652.596
R250 VIN.n1557 VIN.t593 652.596
R251 VIN.n1557 VIN.t631 652.596
R252 VIN.n1556 VIN.t1729 652.596
R253 VIN.n1556 VIN.t1773 652.596
R254 VIN.n1555 VIN.t234 652.596
R255 VIN.n1555 VIN.t285 652.596
R256 VIN.n1554 VIN.t1903 652.596
R257 VIN.n1554 VIN.t1943 652.596
R258 VIN.n1553 VIN.t414 652.596
R259 VIN.n1553 VIN.t1027 652.596
R260 VIN.n1552 VIN.t1553 652.596
R261 VIN.n1552 VIN.t99 652.596
R262 VIN.n1551 VIN.t577 652.596
R263 VIN.n1551 VIN.t1189 652.596
R264 VIN.n1550 VIN.t1711 652.596
R265 VIN.n1550 VIN.t274 652.596
R266 VIN.n1549 VIN.t843 652.596
R267 VIN.n1549 VIN.t1449 652.596
R268 VIN.n1548 VIN.t1885 652.596
R269 VIN.n1548 VIN.t469 652.596
R270 VIN.n1547 VIN.t1593 652.596
R271 VIN.n1547 VIN.t151 652.596
R272 VIN.n119 VIN.t549 652.596
R273 VIN.n119 VIN.t819 652.596
R274 VIN.n118 VIN.t1109 652.596
R275 VIN.n118 VIN.t1385 652.596
R276 VIN.n117 VIN.t38 652.596
R277 VIN.n117 VIN.t385 652.596
R278 VIN.n116 VIN.t1839 652.596
R279 VIN.n116 VIN.t23 652.596
R280 VIN.n115 VIN.t363 652.596
R281 VIN.n115 VIN.t633 652.596
R282 VIN.n114 VIN.t2009 652.596
R283 VIN.n114 VIN.t238 652.596
R284 VIN.n113 VIN.t1131 652.596
R285 VIN.n113 VIN.t1397 652.596
R286 VIN.n112 VIN.t1661 652.596
R287 VIN.n112 VIN.t1945 652.596
R288 VIN.n111 VIN.t1299 652.596
R289 VIN.n111 VIN.t1545 652.596
R290 VIN.n110 VIN.t1221 652.596
R291 VIN.n110 VIN.t1123 652.596
R292 VIN.n109 VIN.t329 652.596
R293 VIN.n109 VIN.t214 652.596
R294 VIN.n108 VIN.t1387 652.596
R295 VIN.n108 VIN.t1297 652.596
R296 VIN.n107 VIN.t487 652.596
R297 VIN.n107 VIN.t398 652.596
R298 VIN.n106 VIN.t1627 652.596
R299 VIN.n106 VIN.t1533 652.596
R300 VIN.n105 VIN.t637 652.596
R301 VIN.n105 VIN.t563 652.596
R302 VIN.n104 VIN.t354 652.596
R303 VIN.n104 VIN.t263 652.596
R304 VIN.n1258 VIN.t611 652.596
R305 VIN.n1258 VIN.t649 652.596
R306 VIN.n1259 VIN.t1167 652.596
R307 VIN.n1259 VIN.t1217 652.596
R308 VIN.n1260 VIN.t128 652.596
R309 VIN.n1260 VIN.t188 652.596
R310 VIN.n1261 VIN.t1917 652.596
R311 VIN.n1261 VIN.t1957 652.596
R312 VIN.n1262 VIN.t451 652.596
R313 VIN.n1262 VIN.t493 652.596
R314 VIN.n1263 VIN.t2081 652.596
R315 VIN.n1263 VIN.t20 652.596
R316 VIN.n1264 VIN.t1195 652.596
R317 VIN.n1264 VIN.t1237 652.596
R318 VIN.n1265 VIN.t1733 652.596
R319 VIN.n1265 VIN.t1777 652.596
R320 VIN.n1266 VIN.t1361 652.596
R321 VIN.n1266 VIN.t1401 652.596
R322 VIN.n1267 VIN.t1253 652.596
R323 VIN.n1267 VIN.t1847 652.596
R324 VIN.n1268 VIN.t367 652.596
R325 VIN.n1268 VIN.t977 652.596
R326 VIN.n1269 VIN.t1409 652.596
R327 VIN.n1269 VIN.t2005 652.596
R328 VIN.n1270 VIN.t523 652.596
R329 VIN.n1270 VIN.t1125 652.596
R330 VIN.n1271 VIN.t1669 652.596
R331 VIN.n1271 VIN.t222 652.596
R332 VIN.n1272 VIN.t677 652.596
R333 VIN.n1272 VIN.t1301 652.596
R334 VIN.n1273 VIN.t404 652.596
R335 VIN.n1273 VIN.t1011 652.596
R336 VIN.n1296 VIN.t1781 652.596
R337 VIN.n1296 VIN.t1655 652.596
R338 VIN.n1297 VIN.t297 652.596
R339 VIN.n1297 VIN.t156 652.596
R340 VIN.n1298 VIN.t1369 652.596
R341 VIN.n1298 VIN.t1229 652.596
R342 VIN.n1299 VIN.t1073 652.596
R343 VIN.n1299 VIN.t947 652.596
R344 VIN.n1300 VIN.t1609 652.596
R345 VIN.n1300 VIN.t1479 652.596
R346 VIN.n1301 VIN.t1239 652.596
R347 VIN.n1301 VIN.t1115 652.596
R348 VIN.n1302 VIN.t342 652.596
R349 VIN.n1302 VIN.t183 652.596
R350 VIN.n1303 VIN.t901 652.596
R351 VIN.n1303 VIN.t759 652.596
R352 VIN.n1304 VIN.t515 652.596
R353 VIN.n1304 VIN.t381 652.596
R354 VIN.n1305 VIN.t897 652.596
R355 VIN.n1305 VIN.t1465 652.596
R356 VIN.n1306 VIN.t2051 652.596
R357 VIN.n1306 VIN.t599 652.596
R358 VIN.n1307 VIN.t1069 652.596
R359 VIN.n1307 VIN.t1635 652.596
R360 VIN.n1308 VIN.t131 652.596
R361 VIN.n1308 VIN.t741 652.596
R362 VIN.n1309 VIN.t1335 652.596
R363 VIN.n1309 VIN.t1913 652.596
R364 VIN.n1310 VIN.t322 652.596
R365 VIN.n1310 VIN.t923 652.596
R366 VIN.n1311 VIN.t2075 652.596
R367 VIN.n1311 VIN.t623 652.596
R368 VIN.n1387 VIN.t1459 652.596
R369 VIN.n1387 VIN.t1495 652.596
R370 VIN.n1388 VIN.t2019 652.596
R371 VIN.n1388 VIN.t2067 652.596
R372 VIN.n1389 VIN.t1037 652.596
R373 VIN.n1389 VIN.t1083 652.596
R374 VIN.n1390 VIN.t737 652.596
R375 VIN.n1390 VIN.t787 652.596
R376 VIN.n1391 VIN.t1311 652.596
R377 VIN.n1391 VIN.t1355 652.596
R378 VIN.n1392 VIN.t919 652.596
R379 VIN.n1392 VIN.t959 652.596
R380 VIN.n1393 VIN.t2057 652.596
R381 VIN.n1393 VIN.t2105 652.596
R382 VIN.n1394 VIN.t573 652.596
R383 VIN.n1394 VIN.t621 652.596
R384 VIN.n1395 VIN.t162 652.596
R385 VIN.n1395 VIN.t205 652.596
R386 VIN.n1396 VIN.t377 652.596
R387 VIN.n1396 VIN.t987 652.596
R388 VIN.n1397 VIN.t1511 652.596
R389 VIN.n1397 VIN.t32 652.596
R390 VIN.n1398 VIN.t539 652.596
R391 VIN.n1398 VIN.t1145 652.596
R392 VIN.n1399 VIN.t1665 652.596
R393 VIN.n1399 VIN.t218 652.596
R394 VIN.n1400 VIN.t803 652.596
R395 VIN.n1400 VIN.t1405 652.596
R396 VIN.n1401 VIN.t1833 652.596
R397 VIN.n1401 VIN.t420 652.596
R398 VIN.n1402 VIN.t1539 652.596
R399 VIN.n1402 VIN.t78 652.596
R400 VIN.n1425 VIN.t1389 652.596
R401 VIN.n1425 VIN.t1423 652.596
R402 VIN.n1424 VIN.t1933 652.596
R403 VIN.n1424 VIN.t1977 652.596
R404 VIN.n1423 VIN.t943 652.596
R405 VIN.n1423 VIN.t993 652.596
R406 VIN.n1422 VIN.t641 652.596
R407 VIN.n1422 VIN.t689 652.596
R408 VIN.n1421 VIN.t1209 652.596
R409 VIN.n1421 VIN.t1257 652.596
R410 VIN.n1420 VIN.t815 652.596
R411 VIN.n1420 VIN.t861 652.596
R412 VIN.n1419 VIN.t1953 652.596
R413 VIN.n1419 VIN.t1997 652.596
R414 VIN.n1418 VIN.t481 652.596
R415 VIN.n1418 VIN.t529 652.596
R416 VIN.n1417 VIN.t11 652.596
R417 VIN.n1417 VIN.t88 652.596
R418 VIN.n1416 VIN.t1207 652.596
R419 VIN.n1416 VIN.t1797 652.596
R420 VIN.n1415 VIN.t309 652.596
R421 VIN.n1415 VIN.t937 652.596
R422 VIN.n1414 VIN.t1377 652.596
R423 VIN.n1414 VIN.t1961 652.596
R424 VIN.n1413 VIN.t477 652.596
R425 VIN.n1413 VIN.t1077 652.596
R426 VIN.n1412 VIN.t1619 652.596
R427 VIN.n1412 VIN.t176 652.596
R428 VIN.n1411 VIN.t629 652.596
R429 VIN.n1411 VIN.t1247 652.596
R430 VIN.n1410 VIN.t346 652.596
R431 VIN.n1410 VIN.t957 652.596
R432 VIN.n135 VIN.t1705 652.596
R433 VIN.n135 VIN.t1749 652.596
R434 VIN.n1280 VIN.t203 652.596
R435 VIN.n1280 VIN.t261 652.596
R436 VIN.n1281 VIN.t1279 652.596
R437 VIN.n1281 VIN.t1331 652.596
R438 VIN.n1282 VIN.t995 652.596
R439 VIN.n1282 VIN.t1041 652.596
R440 VIN.n1283 VIN.t1523 652.596
R441 VIN.n1283 VIN.t1575 652.596
R442 VIN.n1284 VIN.t1157 652.596
R443 VIN.n1284 VIN.t1203 652.596
R444 VIN.n1285 VIN.t236 652.596
R445 VIN.n1285 VIN.t291 652.596
R446 VIN.n1286 VIN.t811 652.596
R447 VIN.n1286 VIN.t857 652.596
R448 VIN.n1287 VIN.t439 652.596
R449 VIN.n1287 VIN.t479 652.596
R450 VIN.n1288 VIN.t2087 652.596
R451 VIN.n1288 VIN.t647 652.596
R452 VIN.n1289 VIN.t1215 652.596
R453 VIN.n1289 VIN.t1803 652.596
R454 VIN.n1290 VIN.t191 652.596
R455 VIN.n1290 VIN.t821 652.596
R456 VIN.n1291 VIN.t1359 652.596
R457 VIN.n1291 VIN.t1949 652.596
R458 VIN.n1292 VIN.t489 652.596
R459 VIN.n1292 VIN.t1089 652.596
R460 VIN.n1293 VIN.t1497 652.596
R461 VIN.n1293 VIN.t8 652.596
R462 VIN.n1294 VIN.t1235 652.596
R463 VIN.n1294 VIN.t1831 652.596
R464 VIN.n1358 VIN.t1801 652.596
R465 VIN.n1358 VIN.t2091 652.596
R466 VIN.n1357 VIN.t314 652.596
R467 VIN.n1357 VIN.t603 652.596
R468 VIN.n1356 VIN.t1379 652.596
R469 VIN.n1356 VIN.t1631 652.596
R470 VIN.n1355 VIN.t1087 652.596
R471 VIN.n1355 VIN.t1367 652.596
R472 VIN.n1354 VIN.t1625 652.596
R473 VIN.n1354 VIN.t1909 652.596
R474 VIN.n1353 VIN.t1251 652.596
R475 VIN.n1353 VIN.t1503 652.596
R476 VIN.n1352 VIN.t348 652.596
R477 VIN.n1352 VIN.t625 652.596
R478 VIN.n1351 VIN.t911 652.596
R479 VIN.n1351 VIN.t1191 652.596
R480 VIN.n1350 VIN.t525 652.596
R481 VIN.n1350 VIN.t789 652.596
R482 VIN.n1349 VIN.t1265 652.596
R483 VIN.n1349 VIN.t1181 652.596
R484 VIN.n1348 VIN.t379 652.596
R485 VIN.n1348 VIN.t279 652.596
R486 VIN.n1347 VIN.t1417 652.596
R487 VIN.n1347 VIN.t1349 652.596
R488 VIN.n1346 VIN.t531 652.596
R489 VIN.n1346 VIN.t455 652.596
R490 VIN.n1345 VIN.t1675 652.596
R491 VIN.n1345 VIN.t1587 652.596
R492 VIN.n1344 VIN.t683 652.596
R493 VIN.n1344 VIN.t615 652.596
R494 VIN.n1343 VIN.t408 652.596
R495 VIN.n1343 VIN.t318 652.596
R496 VIN.n157 VIN.t693 652.596
R497 VIN.n157 VIN.t272 652.596
R498 VIN.n156 VIN.t1263 652.596
R499 VIN.n156 VIN.t837 652.596
R500 VIN.n155 VIN.t243 652.596
R501 VIN.n155 VIN.t1879 652.596
R502 VIN.n154 VIN.t2003 652.596
R503 VIN.n154 VIN.t1583 652.596
R504 VIN.n153 VIN.t537 652.596
R505 VIN.n153 VIN.t59 652.596
R506 VIN.n152 VIN.t96 652.596
R507 VIN.n152 VIN.t1751 652.596
R508 VIN.n151 VIN.t1293 652.596
R509 VIN.n151 VIN.t867 652.596
R510 VIN.n150 VIN.t1829 652.596
R511 VIN.n150 VIN.t1421 652.596
R512 VIN.n149 VIN.t1447 652.596
R513 VIN.n149 VIN.t1045 652.596
R514 VIN.n148 VIN.t435 652.596
R515 VIN.n148 VIN.t841 652.596
R516 VIN.n147 VIN.t1559 652.596
R517 VIN.n147 VIN.t1989 652.596
R518 VIN.n146 VIN.t579 652.596
R519 VIN.n146 VIN.t1017 652.596
R520 VIN.n145 VIN.t1717 652.596
R521 VIN.n145 VIN.t61 652.596
R522 VIN.n144 VIN.t849 652.596
R523 VIN.n144 VIN.t1289 652.596
R524 VIN.n143 VIN.t1889 652.596
R525 VIN.n143 VIN.t267 652.596
R526 VIN.n142 VIN.t1595 652.596
R527 VIN.n142 VIN.t2035 652.596
R528 VIN.n1235 VIN.t333 652.596
R529 VIN.n1235 VIN.t903 652.596
R530 VIN.n1234 VIN.t891 652.596
R531 VIN.n1234 VIN.t1441 652.596
R532 VIN.n1233 VIN.t1931 652.596
R533 VIN.n1233 VIN.t465 652.596
R534 VIN.n1232 VIN.t1643 652.596
R535 VIN.n1232 VIN.t139 652.596
R536 VIN.n1231 VIN.t125 652.596
R537 VIN.n1231 VIN.t717 652.596
R538 VIN.n1230 VIN.t1807 652.596
R539 VIN.n1230 VIN.t331 652.596
R540 VIN.n1229 VIN.t927 652.596
R541 VIN.n1229 VIN.t1467 652.596
R542 VIN.n1228 VIN.t1457 652.596
R543 VIN.n1228 VIN.t2031 652.596
R544 VIN.n1227 VIN.t1097 652.596
R545 VIN.n1227 VIN.t1629 652.596
R546 VIN.n1226 VIN.t1445 652.596
R547 VIN.n1226 VIN.t1505 652.596
R548 VIN.n1225 VIN.t569 652.596
R549 VIN.n1225 VIN.t639 652.596
R550 VIN.n1224 VIN.t1601 652.596
R551 VIN.n1224 VIN.t1679 652.596
R552 VIN.n1223 VIN.t721 652.596
R553 VIN.n1223 VIN.t791 652.596
R554 VIN.n1222 VIN.t1877 652.596
R555 VIN.n1222 VIN.t1951 652.596
R556 VIN.n1221 VIN.t893 652.596
R557 VIN.n1221 VIN.t963 652.596
R558 VIN.n1220 VIN.t607 652.596
R559 VIN.n1220 VIN.t671 652.596
R560 VIN.n1211 VIN.t951 652.596
R561 VIN.n1211 VIN.t999 652.596
R562 VIN.n1210 VIN.t1485 652.596
R563 VIN.n1210 VIN.t1529 652.596
R564 VIN.n1209 VIN.t513 652.596
R565 VIN.n1209 VIN.t559 652.596
R566 VIN.n1208 VIN.t193 652.596
R567 VIN.n1208 VIN.t249 652.596
R568 VIN.n1207 VIN.t767 652.596
R569 VIN.n1207 VIN.t817 652.596
R570 VIN.n1206 VIN.t389 652.596
R571 VIN.n1206 VIN.t445 652.596
R572 VIN.n1205 VIN.t1501 652.596
R573 VIN.n1205 VIN.t1551 652.596
R574 VIN.n1204 VIN.t2079 652.596
R575 VIN.n1204 VIN.t17 652.596
R576 VIN.n1203 VIN.t1677 652.596
R577 VIN.n1203 VIN.t1727 652.596
R578 VIN.n1202 VIN.t26 652.596
R579 VIN.n1202 VIN.t691 652.596
R580 VIN.n1201 VIN.t1261 652.596
R581 VIN.n1201 VIN.t1851 652.596
R582 VIN.n1200 VIN.t245 652.596
R583 VIN.n1200 VIN.t863 652.596
R584 VIN.n1199 VIN.t1399 652.596
R585 VIN.n1199 VIN.t1993 652.596
R586 VIN.n1198 VIN.t533 652.596
R587 VIN.n1198 VIN.t1139 652.596
R588 VIN.n1197 VIN.t1547 652.596
R589 VIN.n1197 VIN.t90 652.596
R590 VIN.n1196 VIN.t1291 652.596
R591 VIN.n1196 VIN.t1881 652.596
R592 VIN.n181 VIN.t1275 652.596
R593 VIN.n181 VIN.t1327 652.596
R594 VIN.n180 VIN.t1817 652.596
R595 VIN.n180 VIN.t1861 652.596
R596 VIN.n179 VIN.t825 652.596
R597 VIN.n179 VIN.t869 652.596
R598 VIN.n178 VIN.t545 652.596
R599 VIN.n178 VIN.t587 652.596
R600 VIN.n177 VIN.t1107 652.596
R601 VIN.n177 VIN.t1149 652.596
R602 VIN.n176 VIN.t701 652.596
R603 VIN.n176 VIN.t745 652.596
R604 VIN.n175 VIN.t1837 652.596
R605 VIN.n175 VIN.t1893 652.596
R606 VIN.n174 VIN.t361 652.596
R607 VIN.n174 VIN.t418 652.596
R608 VIN.n173 VIN.t2007 652.596
R609 VIN.n173 VIN.t2063 652.596
R610 VIN.n172 VIN.t617 652.596
R611 VIN.n172 VIN.t1227 652.596
R612 VIN.n171 VIN.t1765 652.596
R613 VIN.n171 VIN.t340 652.596
R614 VIN.n170 VIN.t779 652.596
R615 VIN.n170 VIN.t1393 652.596
R616 VIN.n169 VIN.t1925 652.596
R617 VIN.n169 VIN.t501 652.596
R618 VIN.n168 VIN.t1055 652.596
R619 VIN.n168 VIN.t1645 652.596
R620 VIN.n167 VIN.t2093 652.596
R621 VIN.n167 VIN.t651 652.596
R622 VIN.n166 VIN.t1795 652.596
R623 VIN.n166 VIN.t373 652.596
R624 VIN.n199 VIN.t1867 652.596
R625 VIN.n199 VIN.t1233 652.596
R626 VIN.n198 VIN.t396 652.596
R627 VIN.n198 VIN.t1771 652.596
R628 VIN.n197 VIN.t1433 652.596
R629 VIN.n197 VIN.t785 652.596
R630 VIN.n196 VIN.t1153 652.596
R631 VIN.n196 VIN.t511 652.596
R632 VIN.n195 VIN.t1691 652.596
R633 VIN.n195 VIN.t1071 652.596
R634 VIN.n194 VIN.t1325 652.596
R635 VIN.n194 VIN.t665 652.596
R636 VIN.n193 VIN.t429 652.596
R637 VIN.n193 VIN.t1809 652.596
R638 VIN.n192 VIN.t979 652.596
R639 VIN.n192 VIN.t325 652.596
R640 VIN.n191 VIN.t581 652.596
R641 VIN.n191 VIN.t1979 652.596
R642 VIN.n190 VIN.t1305 652.596
R643 VIN.n190 VIN.t375 652.596
R644 VIN.n189 VIN.t424 652.596
R645 VIN.n189 VIN.t1515 652.596
R646 VIN.n188 VIN.t1451 652.596
R647 VIN.n188 VIN.t543 652.596
R648 VIN.n187 VIN.t567 652.596
R649 VIN.n187 VIN.t1667 652.596
R650 VIN.n186 VIN.t1721 652.596
R651 VIN.n186 VIN.t805 652.596
R652 VIN.n185 VIN.t731 652.596
R653 VIN.n185 VIN.t1835 652.596
R654 VIN.n184 VIN.t461 652.596
R655 VIN.n184 VIN.t1541 652.596
R656 VIN.n217 VIN.t1285 652.596
R657 VIN.n217 VIN.t1535 652.596
R658 VIN.n216 VIN.t1823 652.596
R659 VIN.n216 VIN.t2107 652.596
R660 VIN.n215 VIN.t833 652.596
R661 VIN.n215 VIN.t1121 652.596
R662 VIN.n214 VIN.t555 652.596
R663 VIN.n214 VIN.t829 652.596
R664 VIN.n213 VIN.t1117 652.596
R665 VIN.n213 VIN.t1391 652.596
R666 VIN.n212 VIN.t709 652.596
R667 VIN.n212 VIN.t1005 652.596
R668 VIN.n211 VIN.t1857 652.596
R669 VIN.n211 VIN.t35 652.596
R670 VIN.n210 VIN.t383 652.596
R671 VIN.n210 VIN.t657 652.596
R672 VIN.n209 VIN.t2023 652.596
R673 VIN.n209 VIN.t251 652.596
R674 VIN.n208 VIN.t985 652.596
R675 VIN.n208 VIN.t895 652.596
R676 VIN.n207 VIN.t41 652.596
R677 VIN.n207 VIN.t2049 652.596
R678 VIN.n206 VIN.t1151 652.596
R679 VIN.n206 VIN.t1067 652.596
R680 VIN.n205 VIN.t220 652.596
R681 VIN.n205 VIN.t133 652.596
R682 VIN.n204 VIN.t1407 652.596
R683 VIN.n204 VIN.t1343 652.596
R684 VIN.n203 VIN.t422 652.596
R685 VIN.n203 VIN.t327 652.596
R686 VIN.n202 VIN.t80 652.596
R687 VIN.n202 VIN.t2085 652.596
R688 VIN.n235 VIN.t1585 652.596
R689 VIN.n235 VIN.t70 652.596
R690 VIN.n234 VIN.t67 652.596
R691 VIN.n234 VIN.t669 652.596
R692 VIN.n233 VIN.t1177 652.596
R693 VIN.n233 VIN.t1707 652.596
R694 VIN.n232 VIN.t873 652.596
R695 VIN.n232 VIN.t1431 652.596
R696 VIN.n231 VIN.t1425 652.596
R697 VIN.n231 VIN.t1985 652.596
R698 VIN.n230 VIN.t1053 652.596
R699 VIN.n230 VIN.t1581 652.596
R700 VIN.n229 VIN.t104 652.596
R701 VIN.n229 VIN.t703 652.596
R702 VIN.n228 VIN.t699 652.596
R703 VIN.n228 VIN.t1271 652.596
R704 VIN.n227 VIN.t299 652.596
R705 VIN.n227 VIN.t871 652.596
R706 VIN.n226 VIN.t1483 652.596
R707 VIN.n226 VIN.t1555 652.596
R708 VIN.n225 VIN.t619 652.596
R709 VIN.n225 VIN.t687 652.596
R710 VIN.n224 VIN.t1651 652.596
R711 VIN.n224 VIN.t1725 652.596
R712 VIN.n223 VIN.t769 652.596
R713 VIN.n223 VIN.t839 652.596
R714 VIN.n222 VIN.t1935 652.596
R715 VIN.n222 VIN.t1995 652.596
R716 VIN.n221 VIN.t945 652.596
R717 VIN.n221 VIN.t1021 652.596
R718 VIN.n220 VIN.t645 652.596
R719 VIN.n220 VIN.t725 652.596
R720 VIN.n253 VIN.t149 652.596
R721 VIN.n253 VIN.t199 652.596
R722 VIN.n252 VIN.t723 652.596
R723 VIN.n252 VIN.t773 652.596
R724 VIN.n251 VIN.t1757 652.596
R725 VIN.n251 VIN.t1813 652.596
R726 VIN.n250 VIN.t1471 652.596
R727 VIN.n250 VIN.t1509 652.596
R728 VIN.n249 VIN.t2039 652.596
R729 VIN.n249 VIN.t2083 652.596
R730 VIN.n248 VIN.t1639 652.596
R731 VIN.n248 VIN.t1681 652.596
R732 VIN.n247 VIN.t747 652.596
R733 VIN.n247 VIN.t797 652.596
R734 VIN.n246 VIN.t1321 652.596
R735 VIN.n246 VIN.t1365 652.596
R736 VIN.n245 VIN.t931 652.596
R737 VIN.n245 VIN.t965 652.596
R738 VIN.n244 VIN.t102 652.596
R739 VIN.n244 VIN.t739 652.596
R740 VIN.n243 VIN.t1315 652.596
R741 VIN.n243 VIN.t1901 652.596
R742 VIN.n242 VIN.t289 652.596
R743 VIN.n242 VIN.t917 652.596
R744 VIN.n241 VIN.t1443 652.596
R745 VIN.n241 VIN.t2055 652.596
R746 VIN.n240 VIN.t575 652.596
R747 VIN.n240 VIN.t1185 652.596
R748 VIN.n239 VIN.t1605 652.596
R749 VIN.n239 VIN.t165 652.596
R750 VIN.n238 VIN.t1345 652.596
R751 VIN.n238 VIN.t1941 652.596
R752 VIN.n271 VIN.t507 652.596
R753 VIN.n271 VIN.t547 652.596
R754 VIN.n270 VIN.t1063 652.596
R755 VIN.n270 VIN.t1111 652.596
R756 VIN.n269 VIN.t2099 652.596
R757 VIN.n269 VIN.t44 652.596
R758 VIN.n268 VIN.t1799 652.596
R759 VIN.n268 VIN.t1849 652.596
R760 VIN.n267 VIN.t311 652.596
R761 VIN.n267 VIN.t369 652.596
R762 VIN.n266 VIN.t1969 652.596
R763 VIN.n266 VIN.t2013 652.596
R764 VIN.n265 VIN.t1079 652.596
R765 VIN.n265 VIN.t1129 652.596
R766 VIN.n264 VIN.t1621 652.596
R767 VIN.n264 VIN.t1671 652.596
R768 VIN.n263 VIN.t1249 652.596
R769 VIN.n263 VIN.t1307 652.596
R770 VIN.n262 VIN.t659 652.596
R771 VIN.n262 VIN.t1273 652.596
R772 VIN.n261 VIN.t1819 652.596
R773 VIN.n261 VIN.t393 652.596
R774 VIN.n260 VIN.t827 652.596
R775 VIN.n260 VIN.t1427 652.596
R776 VIN.n259 VIN.t1965 652.596
R777 VIN.n259 VIN.t541 652.596
R778 VIN.n258 VIN.t1103 652.596
R779 VIN.n258 VIN.t1685 652.596
R780 VIN.n257 VIN.t29 652.596
R781 VIN.n257 VIN.t695 652.596
R782 VIN.n256 VIN.t1843 652.596
R783 VIN.n256 VIN.t431 652.596
R784 VIN.n289 VIN.t410 652.596
R785 VIN.n289 VIN.t467 652.596
R786 VIN.n288 VIN.t967 652.596
R787 VIN.n288 VIN.t1019 652.596
R788 VIN.n287 VIN.t1999 652.596
R789 VIN.n287 VIN.t2059 652.596
R790 VIN.n286 VIN.t1709 652.596
R791 VIN.n286 VIN.t1763 652.596
R792 VIN.n285 VIN.t212 652.596
R793 VIN.n285 VIN.t270 652.596
R794 VIN.n284 VIN.t1883 652.596
R795 VIN.n284 VIN.t1937 652.596
R796 VIN.n283 VIN.t1003 652.596
R797 VIN.n283 VIN.t1049 652.596
R798 VIN.n282 VIN.t1531 652.596
R799 VIN.n282 VIN.t1579 652.596
R800 VIN.n281 VIN.t1173 652.596
R801 VIN.n281 VIN.t1223 652.596
R802 VIN.n280 VIN.t1845 652.596
R803 VIN.n280 VIN.t433 652.596
R804 VIN.n279 VIN.t983 652.596
R805 VIN.n279 VIN.t1563 652.596
R806 VIN.n278 VIN.t2011 652.596
R807 VIN.n278 VIN.t583 652.596
R808 VIN.n277 VIN.t1127 652.596
R809 VIN.n277 VIN.t1719 652.596
R810 VIN.n276 VIN.t224 652.596
R811 VIN.n276 VIN.t851 652.596
R812 VIN.n275 VIN.t1303 652.596
R813 VIN.n275 VIN.t1891 652.596
R814 VIN.n274 VIN.t1013 652.596
R815 VIN.n274 VIN.t1597 652.596
R816 VIN.n307 VIN.t337 652.596
R817 VIN.n307 VIN.t391 652.596
R818 VIN.n306 VIN.t899 652.596
R819 VIN.n306 VIN.t949 652.596
R820 VIN.n305 VIN.t1939 652.596
R821 VIN.n305 VIN.t1983 652.596
R822 VIN.n304 VIN.t1641 652.596
R823 VIN.n304 VIN.t1683 652.596
R824 VIN.n303 VIN.t122 652.596
R825 VIN.n303 VIN.t186 652.596
R826 VIN.n302 VIN.t1811 652.596
R827 VIN.n302 VIN.t1859 652.596
R828 VIN.n301 VIN.t933 652.596
R829 VIN.n301 VIN.t971 652.596
R830 VIN.n300 VIN.t1463 652.596
R831 VIN.n300 VIN.t1499 652.596
R832 VIN.n299 VIN.t1095 652.596
R833 VIN.n299 VIN.t1141 652.596
R834 VIN.n298 VIN.t713 652.596
R835 VIN.n298 VIN.t1337 652.596
R836 VIN.n297 VIN.t1871 652.596
R837 VIN.n297 VIN.t463 652.596
R838 VIN.n296 VIN.t887 652.596
R839 VIN.n296 VIN.t1477 652.596
R840 VIN.n295 VIN.t2029 652.596
R841 VIN.n295 VIN.t597 652.596
R842 VIN.n294 VIN.t1159 652.596
R843 VIN.n294 VIN.t1745 652.596
R844 VIN.n293 VIN.t117 652.596
R845 VIN.n293 VIN.t757 652.596
R846 VIN.n292 VIN.t1915 652.596
R847 VIN.n292 VIN.t491 652.596
R848 VIN.n325 VIN.t453 652.596
R849 VIN.n325 VIN.t1001 652.596
R850 VIN.n324 VIN.t997 652.596
R851 VIN.n324 VIN.t1527 652.596
R852 VIN.n323 VIN.t2027 652.596
R853 VIN.n323 VIN.t557 652.596
R854 VIN.n322 VIN.t1735 652.596
R855 VIN.n322 VIN.t247 652.596
R856 VIN.n321 VIN.t241 652.596
R857 VIN.n321 VIN.t823 652.596
R858 VIN.n320 VIN.t1907 652.596
R859 VIN.n320 VIN.t443 652.596
R860 VIN.n319 VIN.t1023 652.596
R861 VIN.n319 VIN.t1557 652.596
R862 VIN.n318 VIN.t1549 652.596
R863 VIN.n318 VIN.t14 652.596
R864 VIN.n317 VIN.t1187 652.596
R865 VIN.n317 VIN.t1731 652.596
R866 VIN.n316 VIN.t1929 652.596
R867 VIN.n316 VIN.t1991 652.596
R868 VIN.n315 VIN.t1065 652.596
R869 VIN.n315 VIN.t1137 652.596
R870 VIN.n314 VIN.t2101 652.596
R871 VIN.n314 VIN.t85 652.596
R872 VIN.n313 VIN.t1213 652.596
R873 VIN.n313 VIN.t1287 652.596
R874 VIN.n312 VIN.t316 652.596
R875 VIN.n312 VIN.t406 652.596
R876 VIN.n311 VIN.t1381 652.596
R877 VIN.n311 VIN.t1439 652.596
R878 VIN.n310 VIN.t1091 652.596
R879 VIN.n310 VIN.t1169 652.596
R880 VIN.n343 VIN.t1047 652.596
R881 VIN.n343 VIN.t1333 652.596
R882 VIN.n342 VIN.t1577 652.596
R883 VIN.n342 VIN.t1863 652.596
R884 VIN.n341 VIN.t595 652.596
R885 VIN.n341 VIN.t875 652.596
R886 VIN.n340 VIN.t295 652.596
R887 VIN.n340 VIN.t585 652.596
R888 VIN.n339 VIN.t865 652.596
R889 VIN.n339 VIN.t1147 652.596
R890 VIN.n338 VIN.t483 652.596
R891 VIN.n338 VIN.t749 652.596
R892 VIN.n337 VIN.t1607 652.596
R893 VIN.n337 VIN.t1897 652.596
R894 VIN.n336 VIN.t93 652.596
R895 VIN.n336 VIN.t427 652.596
R896 VIN.n335 VIN.t1775 652.596
R897 VIN.n335 VIN.t2061 652.596
R898 VIN.n334 VIN.t571 652.596
R899 VIN.n334 VIN.t499 652.596
R900 VIN.n333 VIN.t1723 652.596
R901 VIN.n333 VIN.t1637 652.596
R902 VIN.n332 VIN.t733 652.596
R903 VIN.n332 VIN.t653 652.596
R904 VIN.n331 VIN.t1875 652.596
R905 VIN.n331 VIN.t1783 652.596
R906 VIN.n330 VIN.t1015 652.596
R907 VIN.n330 VIN.t929 652.596
R908 VIN.n329 VIN.t2047 652.596
R909 VIN.n329 VIN.t1955 652.596
R910 VIN.n328 VIN.t1753 652.596
R911 VIN.n328 VIN.t1659 652.596
R912 VIN.n361 VIN.t667 652.596
R913 VIN.n361 VIN.t719 652.596
R914 VIN.n360 VIN.t1231 652.596
R915 VIN.n360 VIN.t1281 652.596
R916 VIN.n359 VIN.t209 652.596
R917 VIN.n359 VIN.t265 652.596
R918 VIN.n358 VIN.t1981 652.596
R919 VIN.n358 VIN.t2025 652.596
R920 VIN.n357 VIN.t509 652.596
R921 VIN.n357 VIN.t553 652.596
R922 VIN.n356 VIN.t56 652.596
R923 VIN.n356 VIN.t120 652.596
R924 VIN.n355 VIN.t1267 652.596
R925 VIN.n355 VIN.t1317 652.596
R926 VIN.n354 VIN.t1805 652.596
R927 VIN.n354 VIN.t1853 652.596
R928 VIN.n353 VIN.t1419 652.596
R929 VIN.n353 VIN.t1455 652.596
R930 VIN.n352 VIN.t1589 652.596
R931 VIN.n352 VIN.t147 652.596
R932 VIN.n351 VIN.t727 652.596
R933 VIN.n351 VIN.t1347 652.596
R934 VIN.n350 VIN.t1761 652.596
R935 VIN.n350 VIN.t335 652.596
R936 VIN.n349 VIN.t877 652.596
R937 VIN.n349 VIN.t1473 652.596
R938 VIN.n348 VIN.t2033 652.596
R939 VIN.n348 VIN.t605 652.596
R940 VIN.n347 VIN.t1057 652.596
R941 VIN.n347 VIN.t1647 652.596
R942 VIN.n346 VIN.t753 652.596
R943 VIN.n346 VIN.t1375 652.596
R944 VIN.n381 VIN.t1283 652.596
R945 VIN.n381 VIN.t1339 652.596
R946 VIN.n380 VIN.t1825 652.596
R947 VIN.n380 VIN.t1873 652.596
R948 VIN.n379 VIN.t835 652.596
R949 VIN.n379 VIN.t889 652.596
R950 VIN.n378 VIN.t561 652.596
R951 VIN.n378 VIN.t601 652.596
R952 VIN.n377 VIN.t1119 652.596
R953 VIN.n377 VIN.t1163 652.596
R954 VIN.n376 VIN.t715 652.596
R955 VIN.n376 VIN.t765 652.596
R956 VIN.n375 VIN.t1855 652.596
R957 VIN.n375 VIN.t1905 652.596
R958 VIN.n374 VIN.t387 652.596
R959 VIN.n374 VIN.t441 652.596
R960 VIN.n373 VIN.t2021 652.596
R961 VIN.n373 VIN.t2069 652.596
R962 VIN.n372 VIN.t229 652.596
R963 VIN.n372 VIN.t853 652.596
R964 VIN.n371 VIN.t1403 652.596
R965 VIN.n371 VIN.t2001 652.596
R966 VIN.n370 VIN.t412 652.596
R967 VIN.n370 VIN.t1025 652.596
R968 VIN.n369 VIN.t1537 652.596
R969 VIN.n369 VIN.t73 652.596
R970 VIN.n368 VIN.t673 652.596
R971 VIN.n368 VIN.t1295 652.596
R972 VIN.n367 VIN.t1713 652.596
R973 VIN.n367 VIN.t276 652.596
R974 VIN.n366 VIN.t1437 652.596
R975 VIN.n366 VIN.t2045 652.596
R976 VIN.n1098 VIN.t1591 652.596
R977 VIN.n1098 VIN.t1649 652.596
R978 VIN.n1097 VIN.t64 652.596
R979 VIN.n1097 VIN.t142 652.596
R980 VIN.n1096 VIN.t1175 652.596
R981 VIN.n1096 VIN.t1225 652.596
R982 VIN.n1095 VIN.t883 652.596
R983 VIN.n1095 VIN.t935 652.596
R984 VIN.n1094 VIN.t1429 652.596
R985 VIN.n1094 VIN.t1469 652.596
R986 VIN.n1093 VIN.t1051 652.596
R987 VIN.n1093 VIN.t1101 652.596
R988 VIN.n1092 VIN.t106 652.596
R989 VIN.n1092 VIN.t172 652.596
R990 VIN.n1091 VIN.t697 652.596
R991 VIN.n1091 VIN.t743 652.596
R992 VIN.n1090 VIN.t304 652.596
R993 VIN.n1090 VIN.t358 652.596
R994 VIN.n1089 VIN.t763 652.596
R995 VIN.n1089 VIN.t1383 652.596
R996 VIN.n1088 VIN.t1927 652.596
R997 VIN.n1088 VIN.t505 652.596
R998 VIN.n1087 VIN.t941 652.596
R999 VIN.n1087 VIN.t1519 652.596
R1000 VIN.n1086 VIN.t2071 652.596
R1001 VIN.n1086 VIN.t635 652.596
R1002 VIN.n1085 VIN.t1205 652.596
R1003 VIN.n1085 VIN.t1793 652.596
R1004 VIN.n1084 VIN.t181 652.596
R1005 VIN.n1084 VIN.t807 652.596
R1006 VIN.n1083 VIN.t1947 652.596
R1007 VIN.n1083 VIN.t527 652.596
R1008 VIN.n401 VIN.t1693 652.596
R1009 VIN.n401 VIN.t197 652.596
R1010 VIN.n400 VIN.t195 652.596
R1011 VIN.n400 VIN.t777 652.596
R1012 VIN.n399 VIN.t1269 652.596
R1013 VIN.n399 VIN.t1815 652.596
R1014 VIN.n398 VIN.t973 652.596
R1015 VIN.n398 VIN.t1513 652.596
R1016 VIN.n397 VIN.t1507 652.596
R1017 VIN.n397 VIN.t2089 652.596
R1018 VIN.n396 VIN.t1143 652.596
R1019 VIN.n396 VIN.t1689 652.596
R1020 VIN.n395 VIN.t216 652.596
R1021 VIN.n395 VIN.t795 652.596
R1022 VIN.n394 VIN.t793 652.596
R1023 VIN.n394 VIN.t1363 652.596
R1024 VIN.n393 VIN.t416 652.596
R1025 VIN.n393 VIN.t969 652.596
R1026 VIN.n392 VIN.t1975 652.596
R1027 VIN.n392 VIN.t2053 652.596
R1028 VIN.n391 VIN.t1113 652.596
R1029 VIN.n391 VIN.t1183 652.596
R1030 VIN.n390 VIN.t47 652.596
R1031 VIN.n390 VIN.t159 652.596
R1032 VIN.n389 VIN.t1259 652.596
R1033 VIN.n389 VIN.t1341 652.596
R1034 VIN.n388 VIN.t371 652.596
R1035 VIN.n388 VIN.t459 652.596
R1036 VIN.n387 VIN.t1411 652.596
R1037 VIN.n387 VIN.t1481 652.596
R1038 VIN.n386 VIN.t1135 652.596
R1039 VIN.n386 VIN.t1219 652.596
R1040 VIN.n926 VIN.t1312 362.954
R1041 VIN.n1537 VIN.n1536 298.865
R1042 VIN.n1326 VIN.n1325 298.865
R1043 VIN.n751 VIN.t878 274.245
R1044 VIN.n752 VIN.t1694 274.245
R1045 VIN.n753 VIN.t904 274.245
R1046 VIN.n754 VIN.t576 274.245
R1047 VIN.n755 VIN.t1328 274.245
R1048 VIN.n756 VIN.t496 274.245
R1049 VIN.n757 VIN.t1686 274.245
R1050 VIN.n758 VIN.t134 274.245
R1051 VIN.n759 VIN.t1386 274.245
R1052 VIN.n760 VIN.t1376 274.245
R1053 VIN.n761 VIN.t538 274.245
R1054 VIN.n762 VIN.t1068 274.245
R1055 VIN.n763 VIN.t189 274.245
R1056 VIN.n764 VIN.t1416 274.245
R1057 VIN.n765 VIN.t1408 274.245
R1058 VIN.n766 VIN.t578 274.245
R1059 VIN.n767 VIN.t1600 274.245
R1060 VIN.n768 VIN.t244 274.245
R1061 VIN.n769 VIN.t778 274.245
R1062 VIN.n770 VIN.t1450 274.245
R1063 VIN.n771 VIN.t1150 274.245
R1064 VIN.n772 VIN.t1650 274.245
R1065 VIN.n773 VIN.t288 274.245
R1066 VIN.n774 VIN.t826 274.245
R1067 VIN.n775 VIN.t2010 274.245
R1068 VIN.n776 VIN.t886 274.245
R1069 VIN.n777 VIN.t2100 274.245
R1070 VIN.n778 VIN.t732 274.245
R1071 VIN.n779 VIN.t1760 274.245
R1072 VIN.n780 VIN.t411 274.245
R1073 VIN.n781 VIN.t940 274.245
R1074 VIN.n782 VIN.t45 274.245
R1075 VIN.n572 VIN.t1652 274.245
R1076 VIN.n573 VIN.t1520 274.245
R1077 VIN.n574 VIN.t343 274.245
R1078 VIN.n575 VIN.t1772 274.245
R1079 VIN.n576 VIN.t734 274.245
R1080 VIN.n577 VIN.t830 274.245
R1081 VIN.n578 VIN.t1656 274.245
R1082 VIN.n579 VIN.t1080 274.245
R1083 VIN.n580 VIN.t1396 274.245
R1084 VIN.n581 VIN.t1996 274.245
R1085 VIN.n582 VIN.t2104 274.245
R1086 VIN.n583 VIN.t182 274.245
R1087 VIN.n584 VIN.t290 274.245
R1088 VIN.n585 VIN.t624 274.245
R1089 VIN.n586 VIN.t1236 274.245
R1090 VIN.n587 VIN.t866 274.245
R1091 VIN.n588 VIN.t1466 274.245
R1092 VIN.n589 VIN.t1550 274.245
R1093 VIN.n590 VIN.t1892 274.245
R1094 VIN.n591 VIN.t1808 274.245
R1095 VIN.n592 VIN.t33 274.245
R1096 VIN.n593 VIN.t702 274.245
R1097 VIN.n594 VIN.t796 274.245
R1098 VIN.n595 VIN.t1128 274.245
R1099 VIN.n596 VIN.t1048 274.245
R1100 VIN.n597 VIN.t970 274.245
R1101 VIN.n598 VIN.t1556 274.245
R1102 VIN.n599 VIN.t1896 274.245
R1103 VIN.n600 VIN.t1316 274.245
R1104 VIN.n601 VIN.t1904 274.245
R1105 VIN.n602 VIN.t171 274.245
R1106 VIN.n603 VIN.t794 274.245
R1107 VIN.n405 VIN.t1662 274.245
R1108 VIN.n406 VIN.t1566 274.245
R1109 VIN.n407 VIN.t252 274.245
R1110 VIN.n408 VIN.t1700 274.245
R1111 VIN.n409 VIN.t662 274.245
R1112 VIN.n410 VIN.t754 274.245
R1113 VIN.n411 VIN.t846 274.245
R1114 VIN.n412 VIN.t1006 274.245
R1115 VIN.n413 VIN.t1108 274.245
R1116 VIN.n414 VIN.t1932 274.245
R1117 VIN.n415 VIN.t2018 274.245
R1118 VIN.n416 VIN.t296 274.245
R1119 VIN.n417 VIN.t202 274.245
R1120 VIN.n418 VIN.t312 274.245
R1121 VIN.n419 VIN.t1166 274.245
R1122 VIN.n420 VIN.t1262 274.245
R1123 VIN.n421 VIN.t890 274.245
R1124 VIN.n422 VIN.t1484 274.245
R1125 VIN.n423 VIN.t1816 274.245
R1126 VIN.n424 VIN.t394 274.245
R1127 VIN.n425 VIN.t1822 274.245
R1128 VIN.n426 VIN.t65 274.245
R1129 VIN.n427 VIN.t722 274.245
R1130 VIN.n428 VIN.t1062 274.245
R1131 VIN.n429 VIN.t966 274.245
R1132 VIN.n430 VIN.t898 274.245
R1133 VIN.n431 VIN.t996 274.245
R1134 VIN.n432 VIN.t1576 274.245
R1135 VIN.n433 VIN.t1230 274.245
R1136 VIN.n434 VIN.t1824 274.245
R1137 VIN.n435 VIN.t62 274.245
R1138 VIN.n436 VIN.t194 274.245
R1139 VIN.n852 VIN.t370 273.858
R1140 VIN.n851 VIN.t1204 273.858
R1141 VIN.n850 VIN.t672 273.858
R1142 VIN.n849 VIN.t2032 273.858
R1143 VIN.n848 VIN.t1014 273.858
R1144 VIN.n847 VIN.t315 273.858
R1145 VIN.n846 VIN.t1158 273.858
R1146 VIN.n845 VIN.t223 273.858
R1147 VIN.n844 VIN.t1102 273.858
R1148 VIN.n843 VIN.t574 273.858
R1149 VIN.n842 VIN.t1934 273.858
R1150 VIN.n841 VIN.t1406 273.858
R1151 VIN.n840 VIN.t1720 273.858
R1152 VIN.n839 VIN.t1054 273.858
R1153 VIN.n838 VIN.t532 273.858
R1154 VIN.n837 VIN.t1876 273.858
R1155 VIN.n836 VIN.t848 273.858
R1156 VIN.n835 VIN.t1668 273.858
R1157 VIN.n834 VIN.t1674 273.858
R1158 VIN.n833 VIN.t488 273.858
R1159 VIN.n832 VIN.t1334 273.858
R1160 VIN.n831 VIN.t802 273.858
R1161 VIN.n830 VIN.t1618 273.858
R1162 VIN.n829 VIN.t1626 273.858
R1163 VIN.n828 VIN.t448 273.858
R1164 VIN.n827 VIN.t1958 273.858
R1165 VIN.n826 VIN.t750 273.858
R1166 VIN.n825 VIN.t1568 273.858
R1167 VIN.n824 VIN.t842 273.858
R1168 VIN.n823 VIN.t1178 273.858
R1169 VIN.n822 VIN.t1972 273.858
R1170 VIN.n821 VIN.t1154 273.858
R1171 VIN.n888 VIN.t458 273.858
R1172 VIN.n887 VIN.t1792 273.858
R1173 VIN.n886 VIN.t1294 273.858
R1174 VIN.n885 VIN.t604 273.858
R1175 VIN.n884 VIN.t928 273.858
R1176 VIN.n883 VIN.t405 273.858
R1177 VIN.n882 VIN.t1744 273.858
R1178 VIN.n881 VIN.t850 273.858
R1179 VIN.n880 VIN.t1684 273.858
R1180 VIN.n879 VIN.t1184 273.858
R1181 VIN.n878 VIN.t1994 273.858
R1182 VIN.n877 VIN.t1342 273.858
R1183 VIN.n876 VIN.t804 273.858
R1184 VIN.n875 VIN.t1644 273.858
R1185 VIN.n874 VIN.t1138 273.858
R1186 VIN.n873 VIN.t1950 273.858
R1187 VIN.n872 VIN.t1288 273.858
R1188 VIN.n871 VIN.t221 273.858
R1189 VIN.n870 VIN.t1586 273.858
R1190 VIN.n869 VIN.t1088 273.858
R1191 VIN.n868 VIN.t1912 273.858
R1192 VIN.n867 VIN.t1404 273.858
R1193 VIN.n866 VIN.t175 273.858
R1194 VIN.n865 VIN.t1532 273.858
R1195 VIN.n864 VIN.t1042 273.858
R1196 VIN.n863 VIN.t1356 273.858
R1197 VIN.n862 VIN.t1372 273.858
R1198 VIN.n861 VIN.t107 273.858
R1199 VIN.n860 VIN.t1448 273.858
R1200 VIN.n859 VIN.t1758 273.858
R1201 VIN.n858 VIN.t1244 273.858
R1202 VIN.n857 VIN.t550 273.858
R1203 VIN.n709 VIN.t415 273.858
R1204 VIN.n708 VIN.t303 273.858
R1205 VIN.n707 VIN.t2020 273.858
R1206 VIN.n706 VIN.t1418 273.858
R1207 VIN.n705 VIN.t1774 273.858
R1208 VIN.n704 VIN.t1186 273.858
R1209 VIN.n703 VIN.t1094 273.858
R1210 VIN.n702 VIN.t1172 273.858
R1211 VIN.n701 VIN.t1248 273.858
R1212 VIN.n700 VIN.t930 273.858
R1213 VIN.n699 VIN.t298 273.858
R1214 VIN.n698 VIN.t2022 273.858
R1215 VIN.n697 VIN.t580 273.858
R1216 VIN.n696 VIN.t2006 273.858
R1217 VIN.n695 VIN.t1676 273.858
R1218 VIN.n694 VIN.t1096 273.858
R1219 VIN.n693 VIN.t1446 273.858
R1220 VIN.n692 VIN.t1360 273.858
R1221 VIN.n691 VIN.t524 273.858
R1222 VIN.n690 VIN.t438 273.858
R1223 VIN.n689 VIN.t514 273.858
R1224 VIN.n688 VIN.t160 273.858
R1225 VIN.n687 VIN.t9 273.858
R1226 VIN.n686 VIN.t1298 273.858
R1227 VIN.n685 VIN.t1198 273.858
R1228 VIN.n684 VIN.t1060 273.858
R1229 VIN.n683 VIN.t952 273.858
R1230 VIN.n682 VIN.t854 273.858
R1231 VIN.n681 VIN.t1902 273.858
R1232 VIN.n680 VIN.t472 273.858
R1233 VIN.n679 VIN.t1768 273.858
R1234 VIN.n678 VIN.t1868 273.858
R1235 VIN.n672 VIN.t968 273.858
R1236 VIN.n671 VIN.t357 273.858
R1237 VIN.n670 VIN.t2068 273.858
R1238 VIN.n669 VIN.t1454 273.858
R1239 VIN.n668 VIN.t2060 273.858
R1240 VIN.n667 VIN.t1730 273.858
R1241 VIN.n666 VIN.t1140 273.858
R1242 VIN.n665 VIN.t1222 273.858
R1243 VIN.n664 VIN.t1306 273.858
R1244 VIN.n663 VIN.t964 273.858
R1245 VIN.n662 VIN.t870 273.858
R1246 VIN.n661 VIN.t250 273.858
R1247 VIN.n660 VIN.t1978 273.858
R1248 VIN.n659 VIN.t2062 273.858
R1249 VIN.n658 VIN.t1726 273.858
R1250 VIN.n657 VIN.t1628 273.858
R1251 VIN.n656 VIN.t1044 273.858
R1252 VIN.n655 VIN.t1400 273.858
R1253 VIN.n654 VIN.t788 273.858
R1254 VIN.n653 VIN.t478 273.858
R1255 VIN.n652 VIN.t380 273.858
R1256 VIN.n651 VIN.t204 273.858
R1257 VIN.n650 VIN.t86 273.858
R1258 VIN.n649 VIN.t1544 273.858
R1259 VIN.n648 VIN.t1242 273.858
R1260 VIN.n647 VIN.t1826 273.858
R1261 VIN.n646 VIN.t1008 273.858
R1262 VIN.n645 VIN.t908 273.858
R1263 VIN.n644 VIN.t1942 273.858
R1264 VIN.n643 VIN.t516 273.858
R1265 VIN.n642 VIN.t1696 273.858
R1266 VIN.n641 VIN.t1820 273.858
R1267 VIN.n535 VIN.t1512 273.858
R1268 VIN.n534 VIN.t934 273.858
R1269 VIN.n533 VIN.t600 273.858
R1270 VIN.n532 VIN.t2024 273.858
R1271 VIN.n531 VIN.t584 273.858
R1272 VIN.n530 VIN.t246 273.858
R1273 VIN.n529 VIN.t1682 273.858
R1274 VIN.n528 VIN.t1762 273.858
R1275 VIN.n527 VIN.t1848 273.858
R1276 VIN.n526 VIN.t1508 273.858
R1277 VIN.n525 VIN.t1430 273.858
R1278 VIN.n524 VIN.t828 273.858
R1279 VIN.n523 VIN.t510 273.858
R1280 VIN.n522 VIN.t586 273.858
R1281 VIN.n521 VIN.t248 273.858
R1282 VIN.n520 VIN.t137 273.858
R1283 VIN.n519 VIN.t1582 273.858
R1284 VIN.n518 VIN.t1956 273.858
R1285 VIN.n517 VIN.t1366 273.858
R1286 VIN.n516 VIN.t1040 273.858
R1287 VIN.n515 VIN.t946 273.858
R1288 VIN.n514 VIN.t786 273.858
R1289 VIN.n513 VIN.t688 273.858
R1290 VIN.n512 VIN.t21 273.858
R1291 VIN.n511 VIN.t1788 273.858
R1292 VIN.n510 VIN.t355 273.858
R1293 VIN.n509 VIN.t1542 273.858
R1294 VIN.n508 VIN.t1452 273.858
R1295 VIN.n507 VIN.t484 273.858
R1296 VIN.n506 VIN.t1074 273.858
R1297 VIN.n505 VIN.t206 273.858
R1298 VIN.n504 VIN.t349 273.858
R1299 VIN.n503 VIN.t972 273.858
R1300 VIN.n502 VIN.t882 273.858
R1301 VIN.n501 VIN.t560 273.858
R1302 VIN.n500 VIN.t1980 273.858
R1303 VIN.n499 VIN.t294 273.858
R1304 VIN.n498 VIN.t1734 273.858
R1305 VIN.n497 VIN.t1640 273.858
R1306 VIN.n496 VIN.t1708 273.858
R1307 VIN.n495 VIN.t1798 273.858
R1308 VIN.n494 VIN.t1470 273.858
R1309 VIN.n493 VIN.t872 273.858
R1310 VIN.n492 VIN.t554 273.858
R1311 VIN.n491 VIN.t1152 273.858
R1312 VIN.n490 VIN.t544 273.858
R1313 VIN.n489 VIN.t192 273.858
R1314 VIN.n488 VIN.t1642 273.858
R1315 VIN.n487 VIN.t2002 273.858
R1316 VIN.n486 VIN.t1916 273.858
R1317 VIN.n485 VIN.t1086 273.858
R1318 VIN.n484 VIN.t994 273.858
R1319 VIN.n483 VIN.t1072 273.858
R1320 VIN.n482 VIN.t736 273.858
R1321 VIN.n481 VIN.t640 273.858
R1322 VIN.n480 VIN.t1838 273.858
R1323 VIN.n479 VIN.t1738 273.858
R1324 VIN.n478 VIN.t1598 273.858
R1325 VIN.n477 VIN.t1492 273.858
R1326 VIN.n476 VIN.t1414 273.858
R1327 VIN.n475 VIN.t446 273.858
R1328 VIN.n474 VIN.t1028 273.858
R1329 VIN.n473 VIN.t292 273.858
R1330 VIN.n472 VIN.t401 273.858
R1331 VIN.n924 VIN.t1134 273.471
R1332 VIN.n923 VIN.t1946 273.471
R1333 VIN.n922 VIN.t1436 273.471
R1334 VIN.n921 VIN.t752 273.471
R1335 VIN.n920 VIN.t1752 273.471
R1336 VIN.n919 VIN.t1090 273.471
R1337 VIN.n918 VIN.t1914 273.471
R1338 VIN.n917 VIN.t1012 273.471
R1339 VIN.n916 VIN.t1842 273.471
R1340 VIN.n915 VIN.t1344 273.471
R1341 VIN.n914 VIN.t644 273.471
R1342 VIN.n913 VIN.t79 273.471
R1343 VIN.n912 VIN.t460 273.471
R1344 VIN.n911 VIN.t1794 273.471
R1345 VIN.n910 VIN.t1290 273.471
R1346 VIN.n909 VIN.t606 273.471
R1347 VIN.n908 VIN.t1594 273.471
R1348 VIN.n907 VIN.t403 273.471
R1349 VIN.n906 VIN.t407 273.471
R1350 VIN.n905 VIN.t1234 273.471
R1351 VIN.n904 VIN.t2074 273.471
R1352 VIN.n903 VIN.t1538 273.471
R1353 VIN.n902 VIN.t345 273.471
R1354 VIN.n901 VIN.t353 273.471
R1355 VIN.n900 VIN.t1192 273.471
R1356 VIN.n899 VIN.t678 273.471
R1357 VIN.n898 VIN.t1490 273.471
R1358 VIN.n897 VIN.t286 273.471
R1359 VIN.n896 VIN.t1592 273.471
R1360 VIN.n895 VIN.t1918 273.471
R1361 VIN.n894 VIN.t684 273.471
R1362 VIN.n893 VIN.t1898 273.471
R1363 VIN.n815 VIN.t157 273.471
R1364 VIN.n814 VIN.t1518 273.471
R1365 VIN.n813 VIN.t1024 273.471
R1366 VIN.n812 VIN.t334 273.471
R1367 VIN.n811 VIN.t652 273.471
R1368 VIN.n810 VIN.t84 273.471
R1369 VIN.n809 VIN.t1476 273.471
R1370 VIN.n808 VIN.t582 273.471
R1371 VIN.n807 VIN.t1426 273.471
R1372 VIN.n806 VIN.t916 273.471
R1373 VIN.n805 VIN.t1724 273.471
R1374 VIN.n804 VIN.t1066 273.471
R1375 VIN.n803 VIN.t542 273.471
R1376 VIN.n802 VIN.t1392 273.471
R1377 VIN.n801 VIN.t862 273.471
R1378 VIN.n800 VIN.t1678 273.471
R1379 VIN.n799 VIN.t1016 273.471
R1380 VIN.n798 VIN.t2004 273.471
R1381 VIN.n797 VIN.t1348 273.471
R1382 VIN.n796 VIN.t820 273.471
R1383 VIN.n795 VIN.t1634 273.471
R1384 VIN.n794 VIN.t1144 273.471
R1385 VIN.n793 VIN.t1960 273.471
R1386 VIN.n792 VIN.t1296 273.471
R1387 VIN.n791 VIN.t770 273.471
R1388 VIN.n790 VIN.t1092 273.471
R1389 VIN.n789 VIN.t1104 273.471
R1390 VIN.n788 VIN.t1920 273.471
R1391 VIN.n787 VIN.t1188 273.471
R1392 VIN.n786 VIN.t1486 273.471
R1393 VIN.n785 VIN.t980 273.471
R1394 VIN.n784 VIN.t256 273.471
R1395 VIN.n745 VIN.t1182 273.471
R1396 VIN.n744 VIN.t504 273.471
R1397 VIN.n743 VIN.t2000 273.471
R1398 VIN.n742 VIN.t1346 273.471
R1399 VIN.n741 VIN.t1636 273.471
R1400 VIN.n740 VIN.t1136 273.471
R1401 VIN.n739 VIN.t462 273.471
R1402 VIN.n738 VIN.t1562 273.471
R1403 VIN.n737 VIN.t392 273.471
R1404 VIN.n736 VIN.t1900 273.471
R1405 VIN.n735 VIN.t686 273.471
R1406 VIN.n734 VIN.t2048 273.471
R1407 VIN.n733 VIN.t1514 273.471
R1408 VIN.n732 VIN.t338 273.471
R1409 VIN.n731 VIN.t1850 273.471
R1410 VIN.n730 VIN.t638 273.471
R1411 VIN.n729 VIN.t1988 273.471
R1412 VIN.n728 VIN.t976 273.471
R1413 VIN.n727 VIN.t277 273.471
R1414 VIN.n726 VIN.t1802 273.471
R1415 VIN.n725 VIN.t598 273.471
R1416 VIN.n724 VIN.t30 273.471
R1417 VIN.n723 VIN.t936 273.471
R1418 VIN.n722 VIN.t213 273.471
R1419 VIN.n721 VIN.t1754 273.471
R1420 VIN.n720 VIN.t2076 273.471
R1421 VIN.n719 VIN.t2094 273.471
R1422 VIN.n718 VIN.t880 273.471
R1423 VIN.n717 VIN.t97 273.471
R1424 VIN.n716 VIN.t470 273.471
R1425 VIN.n715 VIN.t1966 273.471
R1426 VIN.n714 VIN.t1276 273.471
R1427 VIN.n635 VIN.t215 273.471
R1428 VIN.n634 VIN.t105 273.471
R1429 VIN.n633 VIN.t1854 273.471
R1430 VIN.n632 VIN.t1266 273.471
R1431 VIN.n631 VIN.t1606 273.471
R1432 VIN.n630 VIN.t1022 273.471
R1433 VIN.n629 VIN.t932 273.471
R1434 VIN.n628 VIN.t1002 273.471
R1435 VIN.n627 VIN.t1078 273.471
R1436 VIN.n626 VIN.t746 273.471
R1437 VIN.n625 VIN.t103 273.471
R1438 VIN.n624 VIN.t1856 273.471
R1439 VIN.n623 VIN.t428 273.471
R1440 VIN.n622 VIN.t1836 273.471
R1441 VIN.n621 VIN.t1500 273.471
R1442 VIN.n620 VIN.t926 273.471
R1443 VIN.n619 VIN.t1292 273.471
R1444 VIN.n618 VIN.t1194 273.471
R1445 VIN.n617 VIN.t347 273.471
R1446 VIN.n616 VIN.t235 273.471
R1447 VIN.n615 VIN.t341 273.471
R1448 VIN.n614 VIN.t2056 273.471
R1449 VIN.n613 VIN.t1952 273.471
R1450 VIN.n612 VIN.t1130 273.471
R1451 VIN.n611 VIN.t1032 273.471
R1452 VIN.n610 VIN.t884 273.471
R1453 VIN.n609 VIN.t782 273.471
R1454 VIN.n608 VIN.t680 273.471
R1455 VIN.n607 VIN.t1728 273.471
R1456 VIN.n606 VIN.t280 273.471
R1457 VIN.n605 VIN.t1602 273.471
R1458 VIN.n604 VIN.t1702 273.471
R1459 VIN.n569 VIN.t1142 273.471
R1460 VIN.n568 VIN.t1050 273.471
R1461 VIN.n567 VIN.t714 273.471
R1462 VIN.n566 VIN.t54 273.471
R1463 VIN.n565 VIN.t482 273.471
R1464 VIN.n564 VIN.t1906 273.471
R1465 VIN.n563 VIN.t1810 273.471
R1466 VIN.n562 VIN.t1882 273.471
R1467 VIN.n561 VIN.t1968 273.471
R1468 VIN.n560 VIN.t1638 273.471
R1469 VIN.n559 VIN.t1052 273.471
R1470 VIN.n558 VIN.t708 273.471
R1471 VIN.n557 VIN.t1324 273.471
R1472 VIN.n556 VIN.t700 273.471
R1473 VIN.n555 VIN.t388 273.471
R1474 VIN.n554 VIN.t1806 273.471
R1475 VIN.n553 VIN.t94 273.471
R1476 VIN.n552 VIN.t2080 273.471
R1477 VIN.n551 VIN.t1250 273.471
R1478 VIN.n550 VIN.t1156 273.471
R1479 VIN.n549 VIN.t1238 273.471
R1480 VIN.n548 VIN.t918 273.471
R1481 VIN.n547 VIN.t814 273.471
R1482 VIN.n546 VIN.t2008 273.471
R1483 VIN.n545 VIN.t1922 273.471
R1484 VIN.n544 VIN.t1766 273.471
R1485 VIN.n543 VIN.t1672 273.471
R1486 VIN.n542 VIN.t1572 273.471
R1487 VIN.n541 VIN.t592 273.471
R1488 VIN.n540 VIN.t1196 273.471
R1489 VIN.n539 VIN.t474 273.471
R1490 VIN.n538 VIN.t564 273.471
R1491 VIN.n469 VIN.t776 273.471
R1492 VIN.n468 VIN.t140 273.471
R1493 VIN.n467 VIN.t1872 273.471
R1494 VIN.n466 VIN.t1280 273.471
R1495 VIN.n465 VIN.t1862 273.471
R1496 VIN.n464 VIN.t1526 273.471
R1497 VIN.n463 VIN.t948 273.471
R1498 VIN.n462 VIN.t1018 273.471
R1499 VIN.n461 VIN.t1110 273.471
R1500 VIN.n460 VIN.t772 273.471
R1501 VIN.n459 VIN.t668 273.471
R1502 VIN.n458 VIN.t2106 273.471
R1503 VIN.n457 VIN.t1770 273.471
R1504 VIN.n456 VIN.t1860 273.471
R1505 VIN.n455 VIN.t1528 273.471
R1506 VIN.n454 VIN.t1440 273.471
R1507 VIN.n453 VIN.t836 273.471
R1508 VIN.n452 VIN.t1216 273.471
R1509 VIN.n451 VIN.t602 273.471
R1510 VIN.n450 VIN.t260 273.471
R1511 VIN.n449 VIN.t154 273.471
R1512 VIN.n448 VIN.t2066 273.471
R1513 VIN.n447 VIN.t1976 273.471
R1514 VIN.n446 VIN.t1384 273.471
R1515 VIN.n445 VIN.t1058 273.471
R1516 VIN.n444 VIN.t1632 273.471
R1517 VIN.n443 VIN.t798 273.471
R1518 VIN.n442 VIN.t704 273.471
R1519 VIN.n441 VIN.t1742 273.471
R1520 VIN.n440 VIN.t300 273.471
R1521 VIN.n439 VIN.t1488 273.471
R1522 VIN.n438 VIN.t1614 273.471
R1523 VIN.n924 VIN.t1410 273.082
R1524 VIN.n923 VIN.t180 273.082
R1525 VIN.n922 VIN.t1712 273.082
R1526 VIN.n921 VIN.t1056 273.082
R1527 VIN.n920 VIN.t2046 273.082
R1528 VIN.n919 VIN.t1380 273.082
R1529 VIN.n918 VIN.t115 273.082
R1530 VIN.n917 VIN.t1302 273.082
R1531 VIN.n916 VIN.t27 273.082
R1532 VIN.n915 VIN.t1604 273.082
R1533 VIN.n914 VIN.t944 273.082
R1534 VIN.n913 VIN.t421 273.082
R1535 VIN.n912 VIN.t730 273.082
R1536 VIN.n911 VIN.t2092 273.082
R1537 VIN.n910 VIN.t1546 273.082
R1538 VIN.n909 VIN.t892 273.082
R1539 VIN.n908 VIN.t1888 273.082
R1540 VIN.n907 VIN.t676 273.082
R1541 VIN.n906 VIN.t682 273.082
R1542 VIN.n905 VIN.t1496 273.082
R1543 VIN.n904 VIN.t321 273.082
R1544 VIN.n903 VIN.t1832 273.082
R1545 VIN.n902 VIN.t628 273.082
R1546 VIN.n901 VIN.t636 273.082
R1547 VIN.n900 VIN.t1460 273.082
R1548 VIN.n899 VIN.t974 273.082
R1549 VIN.n898 VIN.t1786 273.082
R1550 VIN.n897 VIN.t590 273.082
R1551 VIN.n896 VIN.t1884 273.082
R1552 VIN.n895 VIN.t143 273.082
R1553 VIN.n894 VIN.t988 273.082
R1554 VIN.n893 VIN.t110 273.082
R1555 VIN.n815 VIN.t1340 273.082
R1556 VIN.n814 VIN.t634 273.082
R1557 VIN.n813 VIN.t71 273.082
R1558 VIN.n812 VIN.t1472 273.082
R1559 VIN.n811 VIN.t1782 273.082
R1560 VIN.n810 VIN.t1286 273.082
R1561 VIN.n809 VIN.t596 273.082
R1562 VIN.n808 VIN.t1718 273.082
R1563 VIN.n807 VIN.t540 273.082
R1564 VIN.n806 VIN.t2054 273.082
R1565 VIN.n805 VIN.t838 273.082
R1566 VIN.n804 VIN.t132 273.082
R1567 VIN.n803 VIN.t1666 273.082
R1568 VIN.n802 VIN.t500 273.082
R1569 VIN.n801 VIN.t1992 273.082
R1570 VIN.n800 VIN.t790 273.082
R1571 VIN.n799 VIN.t60 273.082
R1572 VIN.n798 VIN.t1124 273.082
R1573 VIN.n797 VIN.t454 273.082
R1574 VIN.n796 VIN.t1948 273.082
R1575 VIN.n795 VIN.t740 273.082
R1576 VIN.n794 VIN.t217 273.082
R1577 VIN.n793 VIN.t1076 273.082
R1578 VIN.n792 VIN.t397 273.082
R1579 VIN.n791 VIN.t1910 273.082
R1580 VIN.n790 VIN.t169 273.082
R1581 VIN.n789 VIN.t173 273.082
R1582 VIN.n788 VIN.t1030 273.082
R1583 VIN.n787 VIN.t273 273.082
R1584 VIN.n786 VIN.t612 273.082
R1585 VIN.n785 VIN.t3 273.082
R1586 VIN.n784 VIN.t1412 273.082
R1587 VIN.n745 VIN.t2052 273.082
R1588 VIN.n744 VIN.t1382 273.082
R1589 VIN.n743 VIN.t852 273.082
R1590 VIN.n742 VIN.t146 273.082
R1591 VIN.n741 VIN.t498 273.082
R1592 VIN.n740 VIN.t1990 273.082
R1593 VIN.n739 VIN.t1336 273.082
R1594 VIN.n738 VIN.t432 273.082
R1595 VIN.n737 VIN.t1272 273.082
R1596 VIN.n736 VIN.t738 273.082
R1597 VIN.n735 VIN.t1554 273.082
R1598 VIN.n734 VIN.t894 273.082
R1599 VIN.n733 VIN.t374 273.082
R1600 VIN.n732 VIN.t1226 273.082
R1601 VIN.n731 VIN.t690 273.082
R1602 VIN.n730 VIN.t1504 273.082
R1603 VIN.n729 VIN.t840 273.082
R1604 VIN.n728 VIN.t1846 273.082
R1605 VIN.n727 VIN.t1180 273.082
R1606 VIN.n726 VIN.t646 273.082
R1607 VIN.n725 VIN.t1464 273.082
R1608 VIN.n724 VIN.t986 273.082
R1609 VIN.n723 VIN.t1796 273.082
R1610 VIN.n722 VIN.t1122 273.082
R1611 VIN.n721 VIN.t608 273.082
R1612 VIN.n720 VIN.t924 273.082
R1613 VIN.n719 VIN.t938 273.082
R1614 VIN.n718 VIN.t1746 273.082
R1615 VIN.n717 VIN.t1026 273.082
R1616 VIN.n716 VIN.t1350 273.082
R1617 VIN.n715 VIN.t808 273.082
R1618 VIN.n714 VIN.t51 273.082
R1619 VIN.n635 VIN.t792 273.082
R1620 VIN.n634 VIN.t696 273.082
R1621 VIN.n633 VIN.t386 273.082
R1622 VIN.n632 VIN.t1804 273.082
R1623 VIN.n631 VIN.t91 273.082
R1624 VIN.n630 VIN.t1548 273.082
R1625 VIN.n629 VIN.t1462 273.082
R1626 VIN.n628 VIN.t1530 273.082
R1627 VIN.n627 VIN.t1620 273.082
R1628 VIN.n626 VIN.t1320 273.082
R1629 VIN.n625 VIN.t698 273.082
R1630 VIN.n624 VIN.t382 273.082
R1631 VIN.n623 VIN.t978 273.082
R1632 VIN.n622 VIN.t359 273.082
R1633 VIN.n621 VIN.t2078 273.082
R1634 VIN.n620 VIN.t1456 273.082
R1635 VIN.n619 VIN.t1828 273.082
R1636 VIN.n618 VIN.t1732 273.082
R1637 VIN.n617 VIN.t910 273.082
R1638 VIN.n616 VIN.t810 273.082
R1639 VIN.n615 VIN.t900 273.082
R1640 VIN.n614 VIN.t572 273.082
R1641 VIN.n613 VIN.t480 273.082
R1642 VIN.n612 VIN.t1660 273.082
R1643 VIN.n611 VIN.t1564 273.082
R1644 VIN.n610 VIN.t1434 273.082
R1645 VIN.n609 VIN.t1352 273.082
R1646 VIN.n608 VIN.t1254 273.082
R1647 VIN.n607 VIN.t232 273.082
R1648 VIN.n606 VIN.t844 273.082
R1649 VIN.n605 VIN.t81 273.082
R1650 VIN.n604 VIN.t200 273.082
R1651 VIN.n569 VIN.t1506 273.082
R1652 VIN.n568 VIN.t1428 273.082
R1653 VIN.n567 VIN.t1118 273.082
R1654 VIN.n566 VIN.t508 273.082
R1655 VIN.n565 VIN.t864 273.082
R1656 VIN.n564 VIN.t239 273.082
R1657 VIN.n563 VIN.t121 273.082
R1658 VIN.n562 VIN.t210 273.082
R1659 VIN.n561 VIN.t310 273.082
R1660 VIN.n560 VIN.t2038 273.082
R1661 VIN.n559 VIN.t1424 273.082
R1662 VIN.n558 VIN.t1116 273.082
R1663 VIN.n557 VIN.t1690 273.082
R1664 VIN.n556 VIN.t1106 273.082
R1665 VIN.n555 VIN.t766 273.082
R1666 VIN.n554 VIN.t123 273.082
R1667 VIN.n553 VIN.t536 273.082
R1668 VIN.n552 VIN.t450 273.082
R1669 VIN.n551 VIN.t1624 273.082
R1670 VIN.n550 VIN.t1522 273.082
R1671 VIN.n549 VIN.t1608 273.082
R1672 VIN.n548 VIN.t1310 273.082
R1673 VIN.n547 VIN.t1208 273.082
R1674 VIN.n546 VIN.t362 273.082
R1675 VIN.n545 VIN.t254 273.082
R1676 VIN.n544 VIN.t74 273.082
R1677 VIN.n543 VIN.t2064 273.082
R1678 VIN.n542 VIN.t1970 273.082
R1679 VIN.n541 VIN.t990 273.082
R1680 VIN.n540 VIN.t1560 273.082
R1681 VIN.n539 VIN.t858 273.082
R1682 VIN.n538 VIN.t954 273.082
R1683 VIN.n469 VIN.t1814 273.082
R1684 VIN.n468 VIN.t1224 273.082
R1685 VIN.n467 VIN.t888 273.082
R1686 VIN.n466 VIN.t264 273.082
R1687 VIN.n465 VIN.t874 273.082
R1688 VIN.n464 VIN.t556 273.082
R1689 VIN.n463 VIN.t1982 273.082
R1690 VIN.n462 VIN.t2058 273.082
R1691 VIN.n461 VIN.t42 273.082
R1692 VIN.n460 VIN.t1812 273.082
R1693 VIN.n459 VIN.t1706 273.082
R1694 VIN.n458 VIN.t1120 273.082
R1695 VIN.n457 VIN.t784 273.082
R1696 VIN.n456 VIN.t868 273.082
R1697 VIN.n455 VIN.t558 273.082
R1698 VIN.n454 VIN.t464 273.082
R1699 VIN.n453 VIN.t1878 273.082
R1700 VIN.n452 VIN.t187 273.082
R1701 VIN.n451 VIN.t1630 273.082
R1702 VIN.n450 VIN.t1330 273.082
R1703 VIN.n449 VIN.t1228 273.082
R1704 VIN.n448 VIN.t1082 273.082
R1705 VIN.n447 VIN.t992 273.082
R1706 VIN.n446 VIN.t384 273.082
R1707 VIN.n445 VIN.t2096 273.082
R1708 VIN.n444 VIN.t642 273.082
R1709 VIN.n443 VIN.t1840 273.082
R1710 VIN.n442 VIN.t1740 273.082
R1711 VIN.n441 VIN.t760 273.082
R1712 VIN.n440 VIN.t1370 273.082
R1713 VIN.n439 VIN.t520 273.082
R1714 VIN.n438 VIN.t626 273.082
R1715 VIN.n852 VIN.t1258 272.695
R1716 VIN.n851 VIN.t2070 272.695
R1717 VIN.n850 VIN.t1536 272.695
R1718 VIN.n849 VIN.t876 272.695
R1719 VIN.n848 VIN.t1874 272.695
R1720 VIN.n847 VIN.t1212 272.695
R1721 VIN.n846 VIN.t2028 272.695
R1722 VIN.n845 VIN.t1126 272.695
R1723 VIN.n844 VIN.t1964 272.695
R1724 VIN.n843 VIN.t1442 272.695
R1725 VIN.n842 VIN.t768 272.695
R1726 VIN.n841 VIN.t219 272.695
R1727 VIN.n840 VIN.t566 272.695
R1728 VIN.n839 VIN.t1924 272.695
R1729 VIN.n838 VIN.t1398 272.695
R1730 VIN.n837 VIN.t720 272.695
R1731 VIN.n836 VIN.t1716 272.695
R1732 VIN.n835 VIN.t522 272.695
R1733 VIN.n834 VIN.t530 272.695
R1734 VIN.n833 VIN.t1358 272.695
R1735 VIN.n832 VIN.t129 272.695
R1736 VIN.n831 VIN.t1664 272.695
R1737 VIN.n830 VIN.t476 272.695
R1738 VIN.n829 VIN.t486 272.695
R1739 VIN.n828 VIN.t1318 272.695
R1740 VIN.n827 VIN.t800 272.695
R1741 VIN.n826 VIN.t1616 272.695
R1742 VIN.n825 VIN.t436 272.695
R1743 VIN.n824 VIN.t1710 272.695
R1744 VIN.n823 VIN.t2040 272.695
R1745 VIN.n822 VIN.t812 272.695
R1746 VIN.n821 VIN.t2016 272.695
R1747 VIN.n888 VIN.t1480 272.695
R1748 VIN.n887 VIN.t806 272.695
R1749 VIN.n886 VIN.t275 272.695
R1750 VIN.n885 VIN.t1646 272.695
R1751 VIN.n884 VIN.t1954 272.695
R1752 VIN.n883 VIN.t1438 272.695
R1753 VIN.n882 VIN.t756 272.695
R1754 VIN.n881 VIN.t1890 272.695
R1755 VIN.n880 VIN.t694 272.695
R1756 VIN.n879 VIN.t163 272.695
R1757 VIN.n878 VIN.t1020 272.695
R1758 VIN.n877 VIN.t326 272.695
R1759 VIN.n876 VIN.t1834 272.695
R1760 VIN.n875 VIN.t650 272.695
R1761 VIN.n874 VIN.t89 272.695
R1762 VIN.n873 VIN.t962 272.695
R1763 VIN.n872 VIN.t266 272.695
R1764 VIN.n871 VIN.t1300 272.695
R1765 VIN.n870 VIN.t614 272.695
R1766 VIN.n869 VIN.t6 272.695
R1767 VIN.n868 VIN.t922 272.695
R1768 VIN.n867 VIN.t419 272.695
R1769 VIN.n866 VIN.t1246 272.695
R1770 VIN.n865 VIN.t562 272.695
R1771 VIN.n864 VIN.t2072 272.695
R1772 VIN.n863 VIN.t351 272.695
R1773 VIN.n862 VIN.t364 272.695
R1774 VIN.n861 VIN.t1200 272.695
R1775 VIN.n860 VIN.t468 272.695
R1776 VIN.n859 VIN.t774 272.695
R1777 VIN.n858 VIN.t225 272.695
R1778 VIN.n857 VIN.t1570 272.695
R1779 VIN.n709 VIN.t1974 272.695
R1780 VIN.n708 VIN.t762 272.695
R1781 VIN.n707 VIN.t227 272.695
R1782 VIN.n706 VIN.t1588 272.695
R1783 VIN.n705 VIN.t570 272.695
R1784 VIN.n704 VIN.t1928 272.695
R1785 VIN.n703 VIN.t712 272.695
R1786 VIN.n702 VIN.t1844 272.695
R1787 VIN.n701 VIN.t658 272.695
R1788 VIN.n700 VIN.t100 272.695
R1789 VIN.n699 VIN.t1482 272.695
R1790 VIN.n698 VIN.t984 272.695
R1791 VIN.n697 VIN.t1304 272.695
R1792 VIN.n696 VIN.t616 272.695
R1793 VIN.n695 VIN.t24 272.695
R1794 VIN.n694 VIN.t1444 272.695
R1795 VIN.n693 VIN.t434 272.695
R1796 VIN.n692 VIN.t1252 272.695
R1797 VIN.n691 VIN.t1264 272.695
R1798 VIN.n690 VIN.t2086 272.695
R1799 VIN.n689 VIN.t896 272.695
R1800 VIN.n688 VIN.t376 272.695
R1801 VIN.n687 VIN.t1206 272.695
R1802 VIN.n686 VIN.t1220 272.695
R1803 VIN.n685 VIN.t2036 272.695
R1804 VIN.n684 VIN.t1516 272.695
R1805 VIN.n683 VIN.t319 272.695
R1806 VIN.n682 VIN.t1160 272.695
R1807 VIN.n681 VIN.t413 272.695
R1808 VIN.n680 VIN.t728 272.695
R1809 VIN.n679 VIN.t1524 272.695
R1810 VIN.n678 VIN.t706 272.695
R1811 VIN.n672 VIN.t1362 272.695
R1812 VIN.n671 VIN.t742 272.695
R1813 VIN.n670 VIN.t440 272.695
R1814 VIN.n669 VIN.t1852 272.695
R1815 VIN.n668 VIN.t425 272.695
R1816 VIN.n667 VIN.t12 272.695
R1817 VIN.n666 VIN.t1498 272.695
R1818 VIN.n665 VIN.t1578 272.695
R1819 VIN.n664 VIN.t1670 272.695
R1820 VIN.n663 VIN.t1364 272.695
R1821 VIN.n662 VIN.t1270 272.695
R1822 VIN.n661 VIN.t656 272.695
R1823 VIN.n660 VIN.t323 272.695
R1824 VIN.n659 VIN.t417 272.695
R1825 VIN.n658 VIN.t15 272.695
R1826 VIN.n657 VIN.t2030 272.695
R1827 VIN.n656 VIN.t1420 272.695
R1828 VIN.n655 VIN.t1776 272.695
R1829 VIN.n654 VIN.t1190 272.695
R1830 VIN.n653 VIN.t856 272.695
R1831 VIN.n652 VIN.t758 272.695
R1832 VIN.n651 VIN.t620 272.695
R1833 VIN.n650 VIN.t528 272.695
R1834 VIN.n649 VIN.t1944 272.695
R1835 VIN.n648 VIN.t1612 272.695
R1836 VIN.n647 VIN.t166 272.695
R1837 VIN.n646 VIN.t1394 272.695
R1838 VIN.n645 VIN.t1308 272.695
R1839 VIN.n644 VIN.t284 272.695
R1840 VIN.n643 VIN.t906 272.695
R1841 VIN.n642 VIN.t2102 272.695
R1842 VIN.n641 VIN.t152 272.695
R1843 VIN.n535 VIN.t2088 272.695
R1844 VIN.n534 VIN.t1468 272.695
R1845 VIN.n533 VIN.t1162 272.695
R1846 VIN.n532 VIN.t552 272.695
R1847 VIN.n531 VIN.t1146 272.695
R1848 VIN.n530 VIN.t822 272.695
R1849 VIN.n529 VIN.t184 272.695
R1850 VIN.n528 VIN.t268 272.695
R1851 VIN.n527 VIN.t368 272.695
R1852 VIN.n526 VIN.t2082 272.695
R1853 VIN.n525 VIN.t1984 272.695
R1854 VIN.n524 VIN.t1390 272.695
R1855 VIN.n523 VIN.t1070 272.695
R1856 VIN.n522 VIN.t1148 272.695
R1857 VIN.n521 VIN.t816 272.695
R1858 VIN.n520 VIN.t716 272.695
R1859 VIN.n519 VIN.t57 272.695
R1860 VIN.n518 VIN.t492 272.695
R1861 VIN.n517 VIN.t1908 272.695
R1862 VIN.n516 VIN.t1574 272.695
R1863 VIN.n515 VIN.t1478 272.695
R1864 VIN.n514 VIN.t1354 272.695
R1865 VIN.n513 VIN.t1256 272.695
R1866 VIN.n512 VIN.t632 272.695
R1867 VIN.n511 VIN.t305 272.695
R1868 VIN.n510 VIN.t920 272.695
R1869 VIN.n509 VIN.t2110 272.695
R1870 VIN.n508 VIN.t2014 272.695
R1871 VIN.n507 VIN.t1034 272.695
R1872 VIN.n506 VIN.t1610 272.695
R1873 VIN.n505 VIN.t780 272.695
R1874 VIN.n504 VIN.t912 272.695
R1875 VIN.n503 VIN.t1268 272.695
R1876 VIN.n502 VIN.t1174 272.695
R1877 VIN.n501 VIN.t834 272.695
R1878 VIN.n500 VIN.t208 272.695
R1879 VIN.n499 VIN.t594 272.695
R1880 VIN.n498 VIN.t2026 272.695
R1881 VIN.n497 VIN.t1938 272.695
R1882 VIN.n496 VIN.t1998 272.695
R1883 VIN.n495 VIN.t2098 272.695
R1884 VIN.n494 VIN.t1756 272.695
R1885 VIN.n493 VIN.t1176 272.695
R1886 VIN.n492 VIN.t832 272.695
R1887 VIN.n491 VIN.t1432 272.695
R1888 VIN.n490 VIN.t824 272.695
R1889 VIN.n489 VIN.t512 272.695
R1890 VIN.n488 VIN.t1930 272.695
R1891 VIN.n487 VIN.t242 272.695
R1892 VIN.n486 VIN.t126 272.695
R1893 VIN.n485 VIN.t1378 272.695
R1894 VIN.n484 VIN.t1278 272.695
R1895 VIN.n483 VIN.t1368 272.695
R1896 VIN.n482 VIN.t1036 272.695
R1897 VIN.n481 VIN.t942 272.695
R1898 VIN.n480 VIN.t36 272.695
R1899 VIN.n479 VIN.t2042 272.695
R1900 VIN.n478 VIN.t1894 272.695
R1901 VIN.n477 VIN.t1790 272.695
R1902 VIN.n476 VIN.t1698 272.695
R1903 VIN.n475 VIN.t710 272.695
R1904 VIN.n474 VIN.t1322 272.695
R1905 VIN.n473 VIN.t588 272.695
R1906 VIN.n472 VIN.t674 272.695
R1907 VIN.n17 VIN.t1084 272.5
R1908 VIN.n1574 VIN.t960 272.5
R1909 VIN.n1567 VIN.t1784 272.5
R1910 VIN.n40 VIN.t1210 272.5
R1911 VIN.n1493 VIN.t113 272.5
R1912 VIN.n97 VIN.t230 272.5
R1913 VIN.n1460 VIN.t1098 272.5
R1914 VIN.n101 VIN.t502 272.5
R1915 VIN.n1430 VIN.t818 272.5
R1916 VIN.n1382 VIN.t1422 272.5
R1917 VIN.n1380 VIN.t1494 272.5
R1918 VIN.n132 VIN.t1654 272.5
R1919 VIN.n1363 VIN.t1748 272.5
R1920 VIN.n137 VIN.t2090 272.5
R1921 VIN.n1251 VIN.t648 272.5
R1922 VIN.n159 VIN.t271 272.5
R1923 VIN.n1216 VIN.t902 272.5
R1924 VIN.n163 VIN.t998 272.5
R1925 VIN.n1186 VIN.t1326 272.5
R1926 VIN.n1178 VIN.t1232 272.5
R1927 VIN.n201 VIN.t1534 272.5
R1928 VIN.n1164 VIN.t68 272.5
R1929 VIN.n1156 VIN.t198 272.5
R1930 VIN.n1148 VIN.t546 272.5
R1931 VIN.n273 VIN.t466 272.5
R1932 VIN.n1134 VIN.t390 272.5
R1933 VIN.n1127 VIN.t1000 272.5
R1934 VIN.n1119 VIN.t1332 272.5
R1935 VIN.n1111 VIN.t718 272.5
R1936 VIN.n1103 VIN.t1338 272.5
R1937 VIN.n383 VIN.t1648 272.5
R1938 VIN.n1074 VIN.t196 272.5
R1939 VIN.n926 VIN.t1986 272.5
R1940 VIN.n927 VIN.t494 272.5
R1941 VIN.n928 VIN.t150 272.5
R1942 VIN.n929 VIN.t914 272.5
R1943 VIN.n930 VIN.t0 272.5
R1944 VIN.n931 VIN.t2108 272.5
R1945 VIN.n932 VIN.t1778 272.5
R1946 VIN.n933 VIN.t262 272.5
R1947 VIN.n934 VIN.t956 272.5
R1948 VIN.n935 VIN.t77 272.5
R1949 VIN.n936 VIN.t622 272.5
R1950 VIN.n937 VIN.t1830 272.5
R1951 VIN.n938 VIN.t317 272.5
R1952 VIN.n939 VIN.t1010 272.5
R1953 VIN.n940 VIN.t2034 272.5
R1954 VIN.n941 VIN.t670 272.5
R1955 VIN.n942 VIN.t1880 272.5
R1956 VIN.n943 VIN.t372 272.5
R1957 VIN.n944 VIN.t1540 272.5
R1958 VIN.n945 VIN.t2084 272.5
R1959 VIN.n946 VIN.t724 272.5
R1960 VIN.n947 VIN.t1940 272.5
R1961 VIN.n948 VIN.t430 272.5
R1962 VIN.n949 VIN.t1596 272.5
R1963 VIN.n950 VIN.t490 272.5
R1964 VIN.n951 VIN.t1168 272.5
R1965 VIN.n952 VIN.t1658 272.5
R1966 VIN.n953 VIN.t1374 272.5
R1967 VIN.n954 VIN.t2044 272.5
R1968 VIN.n955 VIN.t526 272.5
R1969 VIN.n956 VIN.t1218 272.5
R1970 VIN.n751 VIN.t1864 272.5
R1971 VIN.n752 VIN.t660 272.5
R1972 VIN.n753 VIN.t1886 272.5
R1973 VIN.n754 VIN.t1552 272.5
R1974 VIN.n755 VIN.t258 272.5
R1975 VIN.n756 VIN.t1474 272.5
R1976 VIN.n757 VIN.t654 272.5
R1977 VIN.n758 VIN.t1170 272.5
R1978 VIN.n759 VIN.t328 272.5
R1979 VIN.n760 VIN.t308 272.5
R1980 VIN.n761 VIN.t1510 272.5
R1981 VIN.n762 VIN.t2050 272.5
R1982 VIN.n763 VIN.t1214 272.5
R1983 VIN.n764 VIN.t378 272.5
R1984 VIN.n765 VIN.t366 272.5
R1985 VIN.n766 VIN.t1558 272.5
R1986 VIN.n767 VIN.t568 272.5
R1987 VIN.n768 VIN.t1260 272.5
R1988 VIN.n769 VIN.t1764 272.5
R1989 VIN.n770 VIN.t423 272.5
R1990 VIN.n771 VIN.t39 272.5
R1991 VIN.n772 VIN.t618 272.5
R1992 VIN.n773 VIN.t1314 272.5
R1993 VIN.n774 VIN.t1818 272.5
R1994 VIN.n775 VIN.t982 272.5
R1995 VIN.n776 VIN.t1870 272.5
R1996 VIN.n777 VIN.t1064 272.5
R1997 VIN.n778 VIN.t1722 272.5
R1998 VIN.n779 VIN.t726 272.5
R1999 VIN.n780 VIN.t1402 272.5
R2000 VIN.n781 VIN.t1926 272.5
R2001 VIN.n782 VIN.t1112 272.5
R2002 VIN.n572 VIN.t518 272.5
R2003 VIN.n573 VIN.t399 272.5
R2004 VIN.n574 VIN.t1240 272.5
R2005 VIN.n575 VIN.t630 272.5
R2006 VIN.n576 VIN.t1622 272.5
R2007 VIN.n577 VIN.t1714 272.5
R2008 VIN.n578 VIN.t534 272.5
R2009 VIN.n579 VIN.t1962 272.5
R2010 VIN.n580 VIN.t237 272.5
R2011 VIN.n581 VIN.t860 272.5
R2012 VIN.n582 VIN.t958 272.5
R2013 VIN.n583 VIN.t1114 272.5
R2014 VIN.n584 VIN.t1202 272.5
R2015 VIN.n585 VIN.t1502 272.5
R2016 VIN.n586 VIN.t18 272.5
R2017 VIN.n587 VIN.t1750 272.5
R2018 VIN.n588 VIN.t330 272.5
R2019 VIN.n589 VIN.t444 272.5
R2020 VIN.n590 VIN.t744 272.5
R2021 VIN.n591 VIN.t664 272.5
R2022 VIN.n592 VIN.t1004 272.5
R2023 VIN.n593 VIN.t1580 272.5
R2024 VIN.n594 VIN.t1680 272.5
R2025 VIN.n595 VIN.t2012 272.5
R2026 VIN.n596 VIN.t1936 272.5
R2027 VIN.n597 VIN.t1858 272.5
R2028 VIN.n598 VIN.t442 272.5
R2029 VIN.n599 VIN.t748 272.5
R2030 VIN.n600 VIN.t118 272.5
R2031 VIN.n601 VIN.t764 272.5
R2032 VIN.n602 VIN.t1100 272.5
R2033 VIN.n603 VIN.t1688 272.5
R2034 VIN.n405 VIN.t1132 272.5
R2035 VIN.n406 VIN.t1038 272.5
R2036 VIN.n407 VIN.t1736 272.5
R2037 VIN.n408 VIN.t1164 272.5
R2038 VIN.n409 VIN.t48 272.5
R2039 VIN.n410 VIN.t177 272.5
R2040 VIN.n411 VIN.t282 272.5
R2041 VIN.n412 VIN.t456 272.5
R2042 VIN.n413 VIN.t548 272.5
R2043 VIN.n414 VIN.t1388 272.5
R2044 VIN.n415 VIN.t1458 272.5
R2045 VIN.n416 VIN.t1780 272.5
R2046 VIN.n417 VIN.t1704 272.5
R2047 VIN.n418 VIN.t1800 272.5
R2048 VIN.n419 VIN.t610 272.5
R2049 VIN.n420 VIN.t692 272.5
R2050 VIN.n421 VIN.t332 272.5
R2051 VIN.n422 VIN.t950 272.5
R2052 VIN.n423 VIN.t1274 272.5
R2053 VIN.n424 VIN.t1866 272.5
R2054 VIN.n425 VIN.t1284 272.5
R2055 VIN.n426 VIN.t1584 272.5
R2056 VIN.n427 VIN.t148 272.5
R2057 VIN.n428 VIN.t506 272.5
R2058 VIN.n429 VIN.t409 272.5
R2059 VIN.n430 VIN.t336 272.5
R2060 VIN.n431 VIN.t452 272.5
R2061 VIN.n432 VIN.t1046 272.5
R2062 VIN.n433 VIN.t666 272.5
R2063 VIN.n434 VIN.t1282 272.5
R2064 VIN.n435 VIN.t1590 272.5
R2065 VIN.n436 VIN.t1692 272.5
R2066 VIN.n1538 VIN.n1537 251.119
R2067 VIN.n1327 VIN.n1326 251.119
R2068 VIN.n61 VIN.n60 237.971
R2069 VIN.n1521 VIN.n1517 237.971
R2070 VIN.n76 VIN.n75 237.971
R2071 VIN.n72 VIN.n71 237.971
R2072 VIN.n1406 VIN.n125 237.971
R2073 VIN.n1314 VIN.n1313 237.971
R2074 VIN.n1279 VIN.n1278 237.971
R2075 VIN.n1339 VIN.n1277 237.971
R2076 VIN.n1536 VIN.n68 144.712
R2077 VIN.n1325 VIN.n1324 144.712
R2078 VIN.n1538 VIN.n62 104.192
R2079 VIN.n1328 VIN.n1327 104.192
R2080 VIN.n956 VIN.n955 90.4538
R2081 VIN.n955 VIN.n954 90.4538
R2082 VIN.n954 VIN.n953 90.4538
R2083 VIN.n953 VIN.n952 90.4538
R2084 VIN.n952 VIN.n951 90.4538
R2085 VIN.n951 VIN.n950 90.4538
R2086 VIN.n950 VIN.n949 90.4538
R2087 VIN.n949 VIN.n948 90.4538
R2088 VIN.n948 VIN.n947 90.4538
R2089 VIN.n947 VIN.n946 90.4538
R2090 VIN.n946 VIN.n945 90.4538
R2091 VIN.n945 VIN.n944 90.4538
R2092 VIN.n944 VIN.n943 90.4538
R2093 VIN.n943 VIN.n942 90.4538
R2094 VIN.n942 VIN.n941 90.4538
R2095 VIN.n941 VIN.n940 90.4538
R2096 VIN.n940 VIN.n939 90.4538
R2097 VIN.n939 VIN.n938 90.4538
R2098 VIN.n938 VIN.n937 90.4538
R2099 VIN.n937 VIN.n936 90.4538
R2100 VIN.n936 VIN.n935 90.4538
R2101 VIN.n935 VIN.n934 90.4538
R2102 VIN.n934 VIN.n933 90.4538
R2103 VIN.n933 VIN.n932 90.4538
R2104 VIN.n932 VIN.n931 90.4538
R2105 VIN.n931 VIN.n930 90.4538
R2106 VIN.n930 VIN.n929 90.4538
R2107 VIN.n929 VIN.n928 90.4538
R2108 VIN.n928 VIN.n927 90.4538
R2109 VIN.n927 VIN.n926 90.4538
R2110 VIN.n957 VIN.n956 78.9338
R2111 VIN.n1005 VIN.n852 74.4965
R2112 VIN.n925 VIN.n924 74.4965
R2113 VIN.n783 VIN.n782 74.4965
R2114 VIN.n1030 VIN.n709 74.4965
R2115 VIN.n636 VIN.n635 74.4965
R2116 VIN.n1053 VIN.n569 74.4965
R2117 VIN.n1060 VIN.n503 74.4965
R2118 VIN.n437 VIN.n436 74.4965
R2119 VIN.n1534 VIN.t2114 71.4264
R2120 VIN.n1540 VIN.t2112 71.4264
R2121 VIN.n1319 VIN.t2142 71.4264
R2122 VIN.n1321 VIN.t2140 71.4264
R2123 VIN.n960 VIN.n959 67.4008
R2124 VIN.n963 VIN.n962 67.4008
R2125 VIN.t2114 VIN.t2122 62.6301
R2126 VIN.t2122 VIN.t2124 62.6301
R2127 VIN.t2124 VIN.t2115 62.6301
R2128 VIN.t2113 VIN.t2126 62.6301
R2129 VIN.t2126 VIN.t2120 62.6301
R2130 VIN.t2120 VIN.t2112 62.6301
R2131 VIN.t2142 VIN.t2132 62.6301
R2132 VIN.t2132 VIN.t2134 62.6301
R2133 VIN.t2134 VIN.t2144 62.6301
R2134 VIN.t2136 VIN.t2146 62.6301
R2135 VIN.t2138 VIN.t2136 62.6301
R2136 VIN.t2140 VIN.t2138 62.6301
R2137 VIN.n852 VIN.n851 54.2725
R2138 VIN.n851 VIN.n850 54.2725
R2139 VIN.n850 VIN.n849 54.2725
R2140 VIN.n849 VIN.n848 54.2725
R2141 VIN.n848 VIN.n847 54.2725
R2142 VIN.n847 VIN.n846 54.2725
R2143 VIN.n846 VIN.n845 54.2725
R2144 VIN.n845 VIN.n844 54.2725
R2145 VIN.n844 VIN.n843 54.2725
R2146 VIN.n843 VIN.n842 54.2725
R2147 VIN.n842 VIN.n841 54.2725
R2148 VIN.n841 VIN.n840 54.2725
R2149 VIN.n840 VIN.n839 54.2725
R2150 VIN.n839 VIN.n838 54.2725
R2151 VIN.n838 VIN.n837 54.2725
R2152 VIN.n837 VIN.n836 54.2725
R2153 VIN.n836 VIN.n835 54.2725
R2154 VIN.n835 VIN.n834 54.2725
R2155 VIN.n834 VIN.n833 54.2725
R2156 VIN.n833 VIN.n832 54.2725
R2157 VIN.n832 VIN.n831 54.2725
R2158 VIN.n831 VIN.n830 54.2725
R2159 VIN.n830 VIN.n829 54.2725
R2160 VIN.n829 VIN.n828 54.2725
R2161 VIN.n828 VIN.n827 54.2725
R2162 VIN.n827 VIN.n826 54.2725
R2163 VIN.n826 VIN.n825 54.2725
R2164 VIN.n825 VIN.n824 54.2725
R2165 VIN.n824 VIN.n823 54.2725
R2166 VIN.n823 VIN.n822 54.2725
R2167 VIN.n822 VIN.n821 54.2725
R2168 VIN.n924 VIN.n923 54.2725
R2169 VIN.n923 VIN.n922 54.2725
R2170 VIN.n922 VIN.n921 54.2725
R2171 VIN.n921 VIN.n920 54.2725
R2172 VIN.n920 VIN.n919 54.2725
R2173 VIN.n919 VIN.n918 54.2725
R2174 VIN.n918 VIN.n917 54.2725
R2175 VIN.n917 VIN.n916 54.2725
R2176 VIN.n916 VIN.n915 54.2725
R2177 VIN.n915 VIN.n914 54.2725
R2178 VIN.n914 VIN.n913 54.2725
R2179 VIN.n913 VIN.n912 54.2725
R2180 VIN.n912 VIN.n911 54.2725
R2181 VIN.n911 VIN.n910 54.2725
R2182 VIN.n910 VIN.n909 54.2725
R2183 VIN.n909 VIN.n908 54.2725
R2184 VIN.n908 VIN.n907 54.2725
R2185 VIN.n907 VIN.n906 54.2725
R2186 VIN.n906 VIN.n905 54.2725
R2187 VIN.n905 VIN.n904 54.2725
R2188 VIN.n904 VIN.n903 54.2725
R2189 VIN.n903 VIN.n902 54.2725
R2190 VIN.n902 VIN.n901 54.2725
R2191 VIN.n901 VIN.n900 54.2725
R2192 VIN.n900 VIN.n899 54.2725
R2193 VIN.n899 VIN.n898 54.2725
R2194 VIN.n898 VIN.n897 54.2725
R2195 VIN.n897 VIN.n896 54.2725
R2196 VIN.n896 VIN.n895 54.2725
R2197 VIN.n895 VIN.n894 54.2725
R2198 VIN.n894 VIN.n893 54.2725
R2199 VIN.n888 VIN.n887 54.2725
R2200 VIN.n887 VIN.n886 54.2725
R2201 VIN.n886 VIN.n885 54.2725
R2202 VIN.n885 VIN.n884 54.2725
R2203 VIN.n884 VIN.n883 54.2725
R2204 VIN.n883 VIN.n882 54.2725
R2205 VIN.n882 VIN.n881 54.2725
R2206 VIN.n881 VIN.n880 54.2725
R2207 VIN.n880 VIN.n879 54.2725
R2208 VIN.n879 VIN.n878 54.2725
R2209 VIN.n878 VIN.n877 54.2725
R2210 VIN.n877 VIN.n876 54.2725
R2211 VIN.n876 VIN.n875 54.2725
R2212 VIN.n875 VIN.n874 54.2725
R2213 VIN.n874 VIN.n873 54.2725
R2214 VIN.n873 VIN.n872 54.2725
R2215 VIN.n872 VIN.n871 54.2725
R2216 VIN.n871 VIN.n870 54.2725
R2217 VIN.n870 VIN.n869 54.2725
R2218 VIN.n869 VIN.n868 54.2725
R2219 VIN.n868 VIN.n867 54.2725
R2220 VIN.n867 VIN.n866 54.2725
R2221 VIN.n866 VIN.n865 54.2725
R2222 VIN.n865 VIN.n864 54.2725
R2223 VIN.n864 VIN.n863 54.2725
R2224 VIN.n863 VIN.n862 54.2725
R2225 VIN.n862 VIN.n861 54.2725
R2226 VIN.n861 VIN.n860 54.2725
R2227 VIN.n860 VIN.n859 54.2725
R2228 VIN.n859 VIN.n858 54.2725
R2229 VIN.n858 VIN.n857 54.2725
R2230 VIN.n815 VIN.n814 54.2725
R2231 VIN.n814 VIN.n813 54.2725
R2232 VIN.n813 VIN.n812 54.2725
R2233 VIN.n812 VIN.n811 54.2725
R2234 VIN.n811 VIN.n810 54.2725
R2235 VIN.n810 VIN.n809 54.2725
R2236 VIN.n809 VIN.n808 54.2725
R2237 VIN.n808 VIN.n807 54.2725
R2238 VIN.n807 VIN.n806 54.2725
R2239 VIN.n806 VIN.n805 54.2725
R2240 VIN.n805 VIN.n804 54.2725
R2241 VIN.n804 VIN.n803 54.2725
R2242 VIN.n803 VIN.n802 54.2725
R2243 VIN.n802 VIN.n801 54.2725
R2244 VIN.n801 VIN.n800 54.2725
R2245 VIN.n800 VIN.n799 54.2725
R2246 VIN.n799 VIN.n798 54.2725
R2247 VIN.n798 VIN.n797 54.2725
R2248 VIN.n797 VIN.n796 54.2725
R2249 VIN.n796 VIN.n795 54.2725
R2250 VIN.n795 VIN.n794 54.2725
R2251 VIN.n794 VIN.n793 54.2725
R2252 VIN.n793 VIN.n792 54.2725
R2253 VIN.n792 VIN.n791 54.2725
R2254 VIN.n791 VIN.n790 54.2725
R2255 VIN.n790 VIN.n789 54.2725
R2256 VIN.n789 VIN.n788 54.2725
R2257 VIN.n788 VIN.n787 54.2725
R2258 VIN.n787 VIN.n786 54.2725
R2259 VIN.n786 VIN.n785 54.2725
R2260 VIN.n785 VIN.n784 54.2725
R2261 VIN.n782 VIN.n781 54.2725
R2262 VIN.n781 VIN.n780 54.2725
R2263 VIN.n780 VIN.n779 54.2725
R2264 VIN.n779 VIN.n778 54.2725
R2265 VIN.n778 VIN.n777 54.2725
R2266 VIN.n777 VIN.n776 54.2725
R2267 VIN.n776 VIN.n775 54.2725
R2268 VIN.n775 VIN.n774 54.2725
R2269 VIN.n774 VIN.n773 54.2725
R2270 VIN.n773 VIN.n772 54.2725
R2271 VIN.n772 VIN.n771 54.2725
R2272 VIN.n771 VIN.n770 54.2725
R2273 VIN.n770 VIN.n769 54.2725
R2274 VIN.n769 VIN.n768 54.2725
R2275 VIN.n768 VIN.n767 54.2725
R2276 VIN.n767 VIN.n766 54.2725
R2277 VIN.n766 VIN.n765 54.2725
R2278 VIN.n765 VIN.n764 54.2725
R2279 VIN.n764 VIN.n763 54.2725
R2280 VIN.n763 VIN.n762 54.2725
R2281 VIN.n762 VIN.n761 54.2725
R2282 VIN.n761 VIN.n760 54.2725
R2283 VIN.n760 VIN.n759 54.2725
R2284 VIN.n759 VIN.n758 54.2725
R2285 VIN.n758 VIN.n757 54.2725
R2286 VIN.n757 VIN.n756 54.2725
R2287 VIN.n756 VIN.n755 54.2725
R2288 VIN.n755 VIN.n754 54.2725
R2289 VIN.n754 VIN.n753 54.2725
R2290 VIN.n753 VIN.n752 54.2725
R2291 VIN.n752 VIN.n751 54.2725
R2292 VIN.n745 VIN.n744 54.2725
R2293 VIN.n744 VIN.n743 54.2725
R2294 VIN.n743 VIN.n742 54.2725
R2295 VIN.n742 VIN.n741 54.2725
R2296 VIN.n741 VIN.n740 54.2725
R2297 VIN.n740 VIN.n739 54.2725
R2298 VIN.n739 VIN.n738 54.2725
R2299 VIN.n738 VIN.n737 54.2725
R2300 VIN.n737 VIN.n736 54.2725
R2301 VIN.n736 VIN.n735 54.2725
R2302 VIN.n735 VIN.n734 54.2725
R2303 VIN.n734 VIN.n733 54.2725
R2304 VIN.n733 VIN.n732 54.2725
R2305 VIN.n732 VIN.n731 54.2725
R2306 VIN.n731 VIN.n730 54.2725
R2307 VIN.n730 VIN.n729 54.2725
R2308 VIN.n729 VIN.n728 54.2725
R2309 VIN.n728 VIN.n727 54.2725
R2310 VIN.n727 VIN.n726 54.2725
R2311 VIN.n726 VIN.n725 54.2725
R2312 VIN.n725 VIN.n724 54.2725
R2313 VIN.n724 VIN.n723 54.2725
R2314 VIN.n723 VIN.n722 54.2725
R2315 VIN.n722 VIN.n721 54.2725
R2316 VIN.n721 VIN.n720 54.2725
R2317 VIN.n720 VIN.n719 54.2725
R2318 VIN.n719 VIN.n718 54.2725
R2319 VIN.n718 VIN.n717 54.2725
R2320 VIN.n717 VIN.n716 54.2725
R2321 VIN.n716 VIN.n715 54.2725
R2322 VIN.n715 VIN.n714 54.2725
R2323 VIN.n709 VIN.n708 54.2725
R2324 VIN.n708 VIN.n707 54.2725
R2325 VIN.n707 VIN.n706 54.2725
R2326 VIN.n706 VIN.n705 54.2725
R2327 VIN.n705 VIN.n704 54.2725
R2328 VIN.n704 VIN.n703 54.2725
R2329 VIN.n703 VIN.n702 54.2725
R2330 VIN.n702 VIN.n701 54.2725
R2331 VIN.n701 VIN.n700 54.2725
R2332 VIN.n700 VIN.n699 54.2725
R2333 VIN.n699 VIN.n698 54.2725
R2334 VIN.n698 VIN.n697 54.2725
R2335 VIN.n697 VIN.n696 54.2725
R2336 VIN.n696 VIN.n695 54.2725
R2337 VIN.n695 VIN.n694 54.2725
R2338 VIN.n694 VIN.n693 54.2725
R2339 VIN.n693 VIN.n692 54.2725
R2340 VIN.n692 VIN.n691 54.2725
R2341 VIN.n691 VIN.n690 54.2725
R2342 VIN.n690 VIN.n689 54.2725
R2343 VIN.n689 VIN.n688 54.2725
R2344 VIN.n688 VIN.n687 54.2725
R2345 VIN.n687 VIN.n686 54.2725
R2346 VIN.n686 VIN.n685 54.2725
R2347 VIN.n685 VIN.n684 54.2725
R2348 VIN.n684 VIN.n683 54.2725
R2349 VIN.n683 VIN.n682 54.2725
R2350 VIN.n682 VIN.n681 54.2725
R2351 VIN.n681 VIN.n680 54.2725
R2352 VIN.n680 VIN.n679 54.2725
R2353 VIN.n679 VIN.n678 54.2725
R2354 VIN.n672 VIN.n671 54.2725
R2355 VIN.n671 VIN.n670 54.2725
R2356 VIN.n670 VIN.n669 54.2725
R2357 VIN.n669 VIN.n668 54.2725
R2358 VIN.n668 VIN.n667 54.2725
R2359 VIN.n667 VIN.n666 54.2725
R2360 VIN.n666 VIN.n665 54.2725
R2361 VIN.n665 VIN.n664 54.2725
R2362 VIN.n664 VIN.n663 54.2725
R2363 VIN.n663 VIN.n662 54.2725
R2364 VIN.n662 VIN.n661 54.2725
R2365 VIN.n661 VIN.n660 54.2725
R2366 VIN.n660 VIN.n659 54.2725
R2367 VIN.n659 VIN.n658 54.2725
R2368 VIN.n658 VIN.n657 54.2725
R2369 VIN.n657 VIN.n656 54.2725
R2370 VIN.n656 VIN.n655 54.2725
R2371 VIN.n655 VIN.n654 54.2725
R2372 VIN.n654 VIN.n653 54.2725
R2373 VIN.n653 VIN.n652 54.2725
R2374 VIN.n652 VIN.n651 54.2725
R2375 VIN.n651 VIN.n650 54.2725
R2376 VIN.n650 VIN.n649 54.2725
R2377 VIN.n649 VIN.n648 54.2725
R2378 VIN.n648 VIN.n647 54.2725
R2379 VIN.n647 VIN.n646 54.2725
R2380 VIN.n646 VIN.n645 54.2725
R2381 VIN.n645 VIN.n644 54.2725
R2382 VIN.n644 VIN.n643 54.2725
R2383 VIN.n643 VIN.n642 54.2725
R2384 VIN.n642 VIN.n641 54.2725
R2385 VIN.n635 VIN.n634 54.2725
R2386 VIN.n634 VIN.n633 54.2725
R2387 VIN.n633 VIN.n632 54.2725
R2388 VIN.n632 VIN.n631 54.2725
R2389 VIN.n631 VIN.n630 54.2725
R2390 VIN.n630 VIN.n629 54.2725
R2391 VIN.n629 VIN.n628 54.2725
R2392 VIN.n628 VIN.n627 54.2725
R2393 VIN.n627 VIN.n626 54.2725
R2394 VIN.n626 VIN.n625 54.2725
R2395 VIN.n625 VIN.n624 54.2725
R2396 VIN.n624 VIN.n623 54.2725
R2397 VIN.n623 VIN.n622 54.2725
R2398 VIN.n622 VIN.n621 54.2725
R2399 VIN.n621 VIN.n620 54.2725
R2400 VIN.n620 VIN.n619 54.2725
R2401 VIN.n619 VIN.n618 54.2725
R2402 VIN.n618 VIN.n617 54.2725
R2403 VIN.n617 VIN.n616 54.2725
R2404 VIN.n616 VIN.n615 54.2725
R2405 VIN.n615 VIN.n614 54.2725
R2406 VIN.n614 VIN.n613 54.2725
R2407 VIN.n613 VIN.n612 54.2725
R2408 VIN.n612 VIN.n611 54.2725
R2409 VIN.n611 VIN.n610 54.2725
R2410 VIN.n610 VIN.n609 54.2725
R2411 VIN.n609 VIN.n608 54.2725
R2412 VIN.n608 VIN.n607 54.2725
R2413 VIN.n607 VIN.n606 54.2725
R2414 VIN.n606 VIN.n605 54.2725
R2415 VIN.n605 VIN.n604 54.2725
R2416 VIN.n603 VIN.n602 54.2725
R2417 VIN.n602 VIN.n601 54.2725
R2418 VIN.n601 VIN.n600 54.2725
R2419 VIN.n600 VIN.n599 54.2725
R2420 VIN.n599 VIN.n598 54.2725
R2421 VIN.n598 VIN.n597 54.2725
R2422 VIN.n597 VIN.n596 54.2725
R2423 VIN.n596 VIN.n595 54.2725
R2424 VIN.n595 VIN.n594 54.2725
R2425 VIN.n594 VIN.n593 54.2725
R2426 VIN.n593 VIN.n592 54.2725
R2427 VIN.n592 VIN.n591 54.2725
R2428 VIN.n591 VIN.n590 54.2725
R2429 VIN.n590 VIN.n589 54.2725
R2430 VIN.n589 VIN.n588 54.2725
R2431 VIN.n588 VIN.n587 54.2725
R2432 VIN.n587 VIN.n586 54.2725
R2433 VIN.n586 VIN.n585 54.2725
R2434 VIN.n585 VIN.n584 54.2725
R2435 VIN.n584 VIN.n583 54.2725
R2436 VIN.n583 VIN.n582 54.2725
R2437 VIN.n582 VIN.n581 54.2725
R2438 VIN.n581 VIN.n580 54.2725
R2439 VIN.n580 VIN.n579 54.2725
R2440 VIN.n579 VIN.n578 54.2725
R2441 VIN.n578 VIN.n577 54.2725
R2442 VIN.n577 VIN.n576 54.2725
R2443 VIN.n576 VIN.n575 54.2725
R2444 VIN.n575 VIN.n574 54.2725
R2445 VIN.n574 VIN.n573 54.2725
R2446 VIN.n573 VIN.n572 54.2725
R2447 VIN.n569 VIN.n568 54.2725
R2448 VIN.n568 VIN.n567 54.2725
R2449 VIN.n567 VIN.n566 54.2725
R2450 VIN.n566 VIN.n565 54.2725
R2451 VIN.n565 VIN.n564 54.2725
R2452 VIN.n564 VIN.n563 54.2725
R2453 VIN.n563 VIN.n562 54.2725
R2454 VIN.n562 VIN.n561 54.2725
R2455 VIN.n561 VIN.n560 54.2725
R2456 VIN.n560 VIN.n559 54.2725
R2457 VIN.n559 VIN.n558 54.2725
R2458 VIN.n558 VIN.n557 54.2725
R2459 VIN.n557 VIN.n556 54.2725
R2460 VIN.n556 VIN.n555 54.2725
R2461 VIN.n555 VIN.n554 54.2725
R2462 VIN.n554 VIN.n553 54.2725
R2463 VIN.n553 VIN.n552 54.2725
R2464 VIN.n552 VIN.n551 54.2725
R2465 VIN.n551 VIN.n550 54.2725
R2466 VIN.n550 VIN.n549 54.2725
R2467 VIN.n549 VIN.n548 54.2725
R2468 VIN.n548 VIN.n547 54.2725
R2469 VIN.n547 VIN.n546 54.2725
R2470 VIN.n546 VIN.n545 54.2725
R2471 VIN.n545 VIN.n544 54.2725
R2472 VIN.n544 VIN.n543 54.2725
R2473 VIN.n543 VIN.n542 54.2725
R2474 VIN.n542 VIN.n541 54.2725
R2475 VIN.n541 VIN.n540 54.2725
R2476 VIN.n540 VIN.n539 54.2725
R2477 VIN.n539 VIN.n538 54.2725
R2478 VIN.n535 VIN.n534 54.2725
R2479 VIN.n534 VIN.n533 54.2725
R2480 VIN.n533 VIN.n532 54.2725
R2481 VIN.n532 VIN.n531 54.2725
R2482 VIN.n531 VIN.n530 54.2725
R2483 VIN.n530 VIN.n529 54.2725
R2484 VIN.n529 VIN.n528 54.2725
R2485 VIN.n528 VIN.n527 54.2725
R2486 VIN.n527 VIN.n526 54.2725
R2487 VIN.n526 VIN.n525 54.2725
R2488 VIN.n525 VIN.n524 54.2725
R2489 VIN.n524 VIN.n523 54.2725
R2490 VIN.n523 VIN.n522 54.2725
R2491 VIN.n522 VIN.n521 54.2725
R2492 VIN.n521 VIN.n520 54.2725
R2493 VIN.n520 VIN.n519 54.2725
R2494 VIN.n519 VIN.n518 54.2725
R2495 VIN.n518 VIN.n517 54.2725
R2496 VIN.n517 VIN.n516 54.2725
R2497 VIN.n516 VIN.n515 54.2725
R2498 VIN.n515 VIN.n514 54.2725
R2499 VIN.n514 VIN.n513 54.2725
R2500 VIN.n513 VIN.n512 54.2725
R2501 VIN.n512 VIN.n511 54.2725
R2502 VIN.n511 VIN.n510 54.2725
R2503 VIN.n510 VIN.n509 54.2725
R2504 VIN.n509 VIN.n508 54.2725
R2505 VIN.n508 VIN.n507 54.2725
R2506 VIN.n507 VIN.n506 54.2725
R2507 VIN.n506 VIN.n505 54.2725
R2508 VIN.n505 VIN.n504 54.2725
R2509 VIN.n503 VIN.n502 54.2725
R2510 VIN.n502 VIN.n501 54.2725
R2511 VIN.n501 VIN.n500 54.2725
R2512 VIN.n500 VIN.n499 54.2725
R2513 VIN.n499 VIN.n498 54.2725
R2514 VIN.n498 VIN.n497 54.2725
R2515 VIN.n497 VIN.n496 54.2725
R2516 VIN.n496 VIN.n495 54.2725
R2517 VIN.n495 VIN.n494 54.2725
R2518 VIN.n494 VIN.n493 54.2725
R2519 VIN.n493 VIN.n492 54.2725
R2520 VIN.n492 VIN.n491 54.2725
R2521 VIN.n491 VIN.n490 54.2725
R2522 VIN.n490 VIN.n489 54.2725
R2523 VIN.n489 VIN.n488 54.2725
R2524 VIN.n488 VIN.n487 54.2725
R2525 VIN.n487 VIN.n486 54.2725
R2526 VIN.n486 VIN.n485 54.2725
R2527 VIN.n485 VIN.n484 54.2725
R2528 VIN.n484 VIN.n483 54.2725
R2529 VIN.n483 VIN.n482 54.2725
R2530 VIN.n482 VIN.n481 54.2725
R2531 VIN.n481 VIN.n480 54.2725
R2532 VIN.n480 VIN.n479 54.2725
R2533 VIN.n479 VIN.n478 54.2725
R2534 VIN.n478 VIN.n477 54.2725
R2535 VIN.n477 VIN.n476 54.2725
R2536 VIN.n476 VIN.n475 54.2725
R2537 VIN.n475 VIN.n474 54.2725
R2538 VIN.n474 VIN.n473 54.2725
R2539 VIN.n473 VIN.n472 54.2725
R2540 VIN.n469 VIN.n468 54.2725
R2541 VIN.n468 VIN.n467 54.2725
R2542 VIN.n467 VIN.n466 54.2725
R2543 VIN.n466 VIN.n465 54.2725
R2544 VIN.n465 VIN.n464 54.2725
R2545 VIN.n464 VIN.n463 54.2725
R2546 VIN.n463 VIN.n462 54.2725
R2547 VIN.n462 VIN.n461 54.2725
R2548 VIN.n461 VIN.n460 54.2725
R2549 VIN.n460 VIN.n459 54.2725
R2550 VIN.n459 VIN.n458 54.2725
R2551 VIN.n458 VIN.n457 54.2725
R2552 VIN.n457 VIN.n456 54.2725
R2553 VIN.n456 VIN.n455 54.2725
R2554 VIN.n455 VIN.n454 54.2725
R2555 VIN.n454 VIN.n453 54.2725
R2556 VIN.n453 VIN.n452 54.2725
R2557 VIN.n452 VIN.n451 54.2725
R2558 VIN.n451 VIN.n450 54.2725
R2559 VIN.n450 VIN.n449 54.2725
R2560 VIN.n449 VIN.n448 54.2725
R2561 VIN.n448 VIN.n447 54.2725
R2562 VIN.n447 VIN.n446 54.2725
R2563 VIN.n446 VIN.n445 54.2725
R2564 VIN.n445 VIN.n444 54.2725
R2565 VIN.n444 VIN.n443 54.2725
R2566 VIN.n443 VIN.n442 54.2725
R2567 VIN.n442 VIN.n441 54.2725
R2568 VIN.n441 VIN.n440 54.2725
R2569 VIN.n440 VIN.n439 54.2725
R2570 VIN.n439 VIN.n438 54.2725
R2571 VIN.n436 VIN.n435 54.2725
R2572 VIN.n435 VIN.n434 54.2725
R2573 VIN.n434 VIN.n433 54.2725
R2574 VIN.n433 VIN.n432 54.2725
R2575 VIN.n432 VIN.n431 54.2725
R2576 VIN.n431 VIN.n430 54.2725
R2577 VIN.n430 VIN.n429 54.2725
R2578 VIN.n429 VIN.n428 54.2725
R2579 VIN.n428 VIN.n427 54.2725
R2580 VIN.n427 VIN.n426 54.2725
R2581 VIN.n426 VIN.n425 54.2725
R2582 VIN.n425 VIN.n424 54.2725
R2583 VIN.n424 VIN.n423 54.2725
R2584 VIN.n423 VIN.n422 54.2725
R2585 VIN.n422 VIN.n421 54.2725
R2586 VIN.n421 VIN.n420 54.2725
R2587 VIN.n420 VIN.n419 54.2725
R2588 VIN.n419 VIN.n418 54.2725
R2589 VIN.n418 VIN.n417 54.2725
R2590 VIN.n417 VIN.n416 54.2725
R2591 VIN.n416 VIN.n415 54.2725
R2592 VIN.n415 VIN.n414 54.2725
R2593 VIN.n414 VIN.n413 54.2725
R2594 VIN.n413 VIN.n412 54.2725
R2595 VIN.n412 VIN.n411 54.2725
R2596 VIN.n411 VIN.n410 54.2725
R2597 VIN.n410 VIN.n409 54.2725
R2598 VIN.n409 VIN.n408 54.2725
R2599 VIN.n408 VIN.n407 54.2725
R2600 VIN.n407 VIN.n406 54.2725
R2601 VIN.n406 VIN.n405 54.2725
R2602 VIN.n1532 VIN.n68 49.6005
R2603 VIN.n1324 VIN.n1323 49.6005
R2604 VIN.n1532 VIN.n1531 48.1783
R2605 VIN.n1323 VIN.n1276 48.1783
R2606 VIN.n997 VIN.n888 47.3605
R2607 VIN.n816 VIN.n815 47.3605
R2608 VIN.n746 VIN.n745 47.3605
R2609 VIN.n673 VIN.n672 47.3605
R2610 VIN.n1047 VIN.n603 47.3605
R2611 VIN.n536 VIN.n535 47.3605
R2612 VIN.n1066 VIN.n469 47.3605
R2613 VIN VIN.n1585 41.4043
R2614 VIN.n1075 VIN.n1073 38.8016
R2615 VIN.t46 VIN.t158 36.315
R2616 VIN.t141 VIN.t46 36.315
R2617 VIN.t63 VIN.t141 36.315
R2618 VIN.t72 VIN.t63 36.315
R2619 VIN.t228 VIN.t72 36.315
R2620 VIN.t119 VIN.t228 36.315
R2621 VIN.t55 VIN.t119 36.315
R2622 VIN.t426 VIN.t55 36.315
R2623 VIN.t92 VIN.t426 36.315
R2624 VIN.t13 VIN.t92 36.315
R2625 VIN.t240 VIN.t13 36.315
R2626 VIN.t185 VIN.t240 36.315
R2627 VIN.t116 VIN.t185 36.315
R2628 VIN.t269 VIN.t116 36.315
R2629 VIN.t211 VIN.t269 36.315
R2630 VIN.t43 VIN.t211 36.315
R2631 VIN.t28 VIN.t43 36.315
R2632 VIN.t164 VIN.t28 36.315
R2633 VIN.t101 VIN.t164 36.315
R2634 VIN.t69 VIN.t101 36.315
R2635 VIN.t66 VIN.t69 36.315
R2636 VIN.t34 VIN.t66 36.315
R2637 VIN.t40 VIN.t34 36.315
R2638 VIN.t324 VIN.t40 36.315
R2639 VIN.t395 VIN.t324 36.315
R2640 VIN.t339 VIN.t395 36.315
R2641 VIN.t360 VIN.t339 36.315
R2642 VIN.t16 VIN.t360 36.315
R2643 VIN.t25 VIN.t16 36.315
R2644 VIN.t138 VIN.t25 36.315
R2645 VIN.t124 VIN.t138 36.315
R2646 VIN.t58 VIN.t95 36.315
R2647 VIN.t95 VIN.t19 36.315
R2648 VIN.t19 VIN.t127 36.315
R2649 VIN.t127 VIN.t278 36.315
R2650 VIN.t278 VIN.t313 36.315
R2651 VIN.t313 VIN.t7 36.315
R2652 VIN.t7 VIN.t190 36.315
R2653 VIN.t190 VIN.t155 36.315
R2654 VIN.t155 VIN.t130 36.315
R2655 VIN.t130 VIN.t31 36.315
R2656 VIN.t31 VIN.t161 36.315
R2657 VIN.t161 VIN.t87 36.315
R2658 VIN.t87 VIN.t10 36.315
R2659 VIN.t10 VIN.t22 36.315
R2660 VIN.t22 VIN.t37 36.315
R2661 VIN.t37 VIN.t306 36.315
R2662 VIN.t306 VIN.t135 36.315
R2663 VIN.t135 VIN.t167 36.315
R2664 VIN.t167 VIN.t75 36.315
R2665 VIN.t75 VIN.t1 36.315
R2666 VIN.t1 VIN.t178 36.315
R2667 VIN.t178 VIN.t108 36.315
R2668 VIN.t108 VIN.t49 36.315
R2669 VIN.t49 VIN.t98 36.315
R2670 VIN.t98 VIN.t233 36.315
R2671 VIN.t233 VIN.t301 36.315
R2672 VIN.t301 VIN.t144 36.315
R2673 VIN.t144 VIN.t4 36.315
R2674 VIN.t4 VIN.t82 36.315
R2675 VIN.t82 VIN.t52 36.315
R2676 VIN.t52 VIN.t111 36.315
R2677 VIN.n1542 VIN.n62 35.7125
R2678 VIN.n1328 VIN.n124 35.7125
R2679 VIN.n1543 VIN.n1542 34.6885
R2680 VIN.n1408 VIN.n124 34.6885
R2681 VIN.t2115 VIN.n69 31.3153
R2682 VIN.n69 VIN.t2113 31.3153
R2683 VIN.n1331 VIN.t2144 31.3153
R2684 VIN.n1331 VIN.t2146 31.3153
R2685 VIN.n960 VIN.n958 31.1036
R2686 VIN.n963 VIN.n961 31.1036
R2687 VIN.n1542 VIN.n1541 30.8338
R2688 VIN.n1541 VIN.n1540 30.8338
R2689 VIN.n1533 VIN.n1532 30.8338
R2690 VIN.n1534 VIN.n1533 30.8338
R2691 VIN.n1316 VIN.n124 30.8338
R2692 VIN.n1321 VIN.n1316 30.8338
R2693 VIN.n1323 VIN.n1315 30.8338
R2694 VIN.n1319 VIN.n1315 30.8338
R2695 VIN.n68 VIN.n67 29.0758
R2696 VIN.n1329 VIN.n1324 29.0758
R2697 VIN.n67 VIN.n62 28.5252
R2698 VIN.n1329 VIN.n1328 28.5252
R2699 VIN.n1240 VIN.t124 18.1577
R2700 VIN.n1240 VIN.t58 18.1577
R2701 VIN.n60 VIN.t2121 17.3126
R2702 VIN.n60 VIN.t2118 17.3126
R2703 VIN.n1517 VIN.t2119 17.3126
R2704 VIN.n1517 VIN.t2127 17.3126
R2705 VIN.n75 VIN.t2125 17.3126
R2706 VIN.n75 VIN.t2117 17.3126
R2707 VIN.n71 VIN.t2116 17.3126
R2708 VIN.n71 VIN.t2123 17.3126
R2709 VIN.n125 VIN.t2150 17.3126
R2710 VIN.n125 VIN.t2141 17.3126
R2711 VIN.n1313 VIN.t2147 17.3126
R2712 VIN.n1313 VIN.t2149 17.3126
R2713 VIN.n1278 VIN.t2148 17.3126
R2714 VIN.n1278 VIN.t2145 17.3126
R2715 VIN.n1277 VIN.t2143 17.3126
R2716 VIN.n1277 VIN.t2151 17.3126
R2717 VIN.n959 VIN.t2130 16.5719
R2718 VIN.n959 VIN.t2131 16.5719
R2719 VIN.n962 VIN.t2128 16.5719
R2720 VIN.n962 VIN.t2129 16.5719
R2721 VIN.n1527 VIN.n1526 14.7205
R2722 VIN.n1338 VIN.n1337 14.7205
R2723 VIN.n1520 VIN.n1518 14.0805
R2724 VIN.n1405 VIN.n126 14.0805
R2725 VIN.n1522 VIN.n1521 11.7765
R2726 VIN.n1333 VIN.n1314 11.7765
R2727 VIN.n1544 VIN.n1543 11.5205
R2728 VIN.n1408 VIN.n1407 11.5205
R2729 VIN.n1523 VIN.n76 10.5605
R2730 VIN.n1334 VIN.n1279 10.5605
R2731 VIN.n1530 VIN.n72 9.9205
R2732 VIN.n1340 VIN.n1339 9.9205
R2733 VIN.n1531 VIN.n1530 9.8565
R2734 VIN.n1340 VIN.n1276 9.8565
R2735 VIN.n1537 VIN.n66 8.40959
R2736 VIN.n69 VIN.n66 8.40959
R2737 VIN.n1536 VIN.n1535 8.40959
R2738 VIN.n1535 VIN.n1534 8.40959
R2739 VIN.n1539 VIN.n1538 8.40959
R2740 VIN.n1540 VIN.n1539 8.40959
R2741 VIN.n67 VIN.n65 8.40959
R2742 VIN.n69 VIN.n65 8.40959
R2743 VIN.n67 VIN.n64 8.40959
R2744 VIN.n69 VIN.n64 8.40959
R2745 VIN.n1522 VIN.n63 8.40959
R2746 VIN.n69 VIN.n63 8.40959
R2747 VIN.n1326 VIN.n1318 8.40959
R2748 VIN.n1331 VIN.n1318 8.40959
R2749 VIN.n1325 VIN.n1320 8.40959
R2750 VIN.n1320 VIN.n1319 8.40959
R2751 VIN.n1327 VIN.n1322 8.40959
R2752 VIN.n1322 VIN.n1321 8.40959
R2753 VIN.n1330 VIN.n1329 8.40959
R2754 VIN.n1331 VIN.n1330 8.40959
R2755 VIN.n1329 VIN.n1317 8.40959
R2756 VIN.n1331 VIN.n1317 8.40959
R2757 VIN.n1333 VIN.n1332 8.40959
R2758 VIN.n1332 VIN.n1331 8.40959
R2759 VIN.n1544 VIN.n61 7.3605
R2760 VIN.n1407 VIN.n1406 7.3605
R2761 VIN.n1518 VIN.n61 6.7205
R2762 VIN.n1406 VIN.n1405 6.7205
R2763 VIN.n1531 VIN.n70 5.7745
R2764 VIN.n1276 VIN.n1274 5.7745
R2765 VIN.n984 VIN.n983 4.538
R2766 VIN.n967 VIN.n964 4.5005
R2767 VIN.n983 VIN.n982 4.5005
R2768 VIN.n982 VIN.n981 4.5005
R2769 VIN.n1072 VIN.n403 4.26717
R2770 VIN.n1068 VIN.n1067 4.26717
R2771 VIN.n1065 VIN.n470 4.26717
R2772 VIN.n1061 VIN.n470 4.26717
R2773 VIN.n1059 VIN.n1058 4.26717
R2774 VIN.n1055 VIN.n1054 4.26717
R2775 VIN.n1052 VIN.n570 4.26717
R2776 VIN.n1048 VIN.n570 4.26717
R2777 VIN.n1046 VIN.n1045 4.26717
R2778 VIN.n1039 VIN.n640 4.26717
R2779 VIN.n1039 VIN.n1038 4.26717
R2780 VIN.n1031 VIN.n677 4.26717
R2781 VIN.n1029 VIN.n710 4.26717
R2782 VIN.n1022 VIN.n1021 4.26717
R2783 VIN.n1021 VIN.n747 4.26717
R2784 VIN.n1014 VIN.n1013 4.26717
R2785 VIN.n1006 VIN.n820 4.26717
R2786 VIN.n1006 VIN.n1005 4.26717
R2787 VIN.n1005 VIN.n853 4.26717
R2788 VIN.n998 VIN.n853 4.26717
R2789 VIN.n996 VIN.n889 4.26717
R2790 VIN.n989 VIN.n988 4.26717
R2791 VIN.n1527 VIN.n72 4.1605
R2792 VIN.n1526 VIN.n76 4.1605
R2793 VIN.n1339 VIN.n1338 4.1605
R2794 VIN.n1337 VIN.n1279 4.1605
R2795 VIN.n1543 VIN.n59 4.1105
R2796 VIN.n1409 VIN.n1408 4.1105
R2797 VIN.n958 VIN.t2137 4.08121
R2798 VIN.n958 VIN.t2139 4.08121
R2799 VIN.n961 VIN.t2133 4.08121
R2800 VIN.n961 VIN.t2135 4.08121
R2801 VIN.n1054 VIN.n1053 3.9624
R2802 VIN.n677 VIN.n673 3.9624
R2803 VIN.n1073 VIN.n402 3.86105
R2804 VIN.n985 VIN.n957 3.71002
R2805 VIN.n1060 VIN.n1059 3.65764
R2806 VIN.n746 VIN.n710 3.65764
R2807 VIN.n988 VIN.n957 3.65764
R2808 VIN.n1067 VIN.n1066 3.35288
R2809 VIN.n1014 VIN.n783 3.35288
R2810 VIN.n925 VIN.n889 3.35288
R2811 VIN.n1076 VIN.n1075 3.10874
R2812 VIN.n1072 VIN.n1071 3.1005
R2813 VIN.n1070 VIN.n403 3.1005
R2814 VIN.n1069 VIN.n1068 3.1005
R2815 VIN.n1067 VIN.n404 3.1005
R2816 VIN.n1065 VIN.n1064 3.1005
R2817 VIN.n1063 VIN.n470 3.1005
R2818 VIN.n1062 VIN.n1061 3.1005
R2819 VIN.n1059 VIN.n471 3.1005
R2820 VIN.n1058 VIN.n1057 3.1005
R2821 VIN.n1056 VIN.n1055 3.1005
R2822 VIN.n1054 VIN.n537 3.1005
R2823 VIN.n1052 VIN.n1051 3.1005
R2824 VIN.n1050 VIN.n570 3.1005
R2825 VIN.n1049 VIN.n1048 3.1005
R2826 VIN.n1046 VIN.n571 3.1005
R2827 VIN.n1045 VIN.n1044 3.1005
R2828 VIN.n640 VIN.n637 3.1005
R2829 VIN.n1040 VIN.n1039 3.1005
R2830 VIN.n1038 VIN.n1037 3.1005
R2831 VIN.n677 VIN.n674 3.1005
R2832 VIN.n1032 VIN.n1031 3.1005
R2833 VIN.n1029 VIN.n1028 3.1005
R2834 VIN.n711 VIN.n710 3.1005
R2835 VIN.n1023 VIN.n1022 3.1005
R2836 VIN.n1021 VIN.n1020 3.1005
R2837 VIN.n748 VIN.n747 3.1005
R2838 VIN.n1015 VIN.n1014 3.1005
R2839 VIN.n1013 VIN.n1012 3.1005
R2840 VIN.n820 VIN.n817 3.1005
R2841 VIN.n1007 VIN.n1006 3.1005
R2842 VIN.n1005 VIN.n1004 3.1005
R2843 VIN.n854 VIN.n853 3.1005
R2844 VIN.n999 VIN.n998 3.1005
R2845 VIN.n996 VIN.n995 3.1005
R2846 VIN.n890 VIN.n889 3.1005
R2847 VIN.n990 VIN.n989 3.1005
R2848 VIN.n988 VIN.n987 3.1005
R2849 VIN.n1585 VIN.n1584 3.1005
R2850 VIN.n1583 VIN.n1582 3.1005
R2851 VIN.n1580 VIN.n1579 3.1005
R2852 VIN.n1577 VIN.n19 3.1005
R2853 VIN.n1576 VIN.n1575 3.1005
R2854 VIN.n1573 VIN.n36 3.1005
R2855 VIN.n1570 VIN.n37 3.1005
R2856 VIN.n1569 VIN.n1568 3.1005
R2857 VIN.n1566 VIN.n39 3.1005
R2858 VIN.n1565 VIN.n1564 3.1005
R2859 VIN.n1496 VIN.n78 3.1005
R2860 VIN.n1498 VIN.n1497 3.1005
R2861 VIN.n1494 VIN.n77 3.1005
R2862 VIN.n1492 VIN.n1491 3.1005
R2863 VIN.n1490 VIN.n79 3.1005
R2864 VIN.n1487 VIN.n1486 3.1005
R2865 VIN.n1485 VIN.n1484 3.1005
R2866 VIN.n1483 VIN.n98 3.1005
R2867 VIN.n1482 VIN.n1481 3.1005
R2868 VIN.n1462 VIN.n1461 3.1005
R2869 VIN.n1459 VIN.n100 3.1005
R2870 VIN.n1458 VIN.n1457 3.1005
R2871 VIN.n1439 VIN.n1438 3.1005
R2872 VIN.n1436 VIN.n1435 3.1005
R2873 VIN.n1433 VIN.n103 3.1005
R2874 VIN.n1432 VIN.n1431 3.1005
R2875 VIN.n1429 VIN.n120 3.1005
R2876 VIN.n122 VIN.n121 3.1005
R2877 VIN.n1383 VIN.n129 3.1005
R2878 VIN.n1385 VIN.n1384 3.1005
R2879 VIN.n1381 VIN.n128 3.1005
R2880 VIN.n1379 VIN.n1378 3.1005
R2881 VIN.n1376 VIN.n1375 3.1005
R2882 VIN.n1374 VIN.n1373 3.1005
R2883 VIN.n1372 VIN.n1371 3.1005
R2884 VIN.n1370 VIN.n133 3.1005
R2885 VIN.n1366 VIN.n134 3.1005
R2886 VIN.n1365 VIN.n1364 3.1005
R2887 VIN.n1362 VIN.n136 3.1005
R2888 VIN.n1361 VIN.n1360 3.1005
R2889 VIN.n1254 VIN.n140 3.1005
R2890 VIN.n1256 VIN.n1255 3.1005
R2891 VIN.n1252 VIN.n139 3.1005
R2892 VIN.n1250 VIN.n1249 3.1005
R2893 VIN.n1248 VIN.n141 3.1005
R2894 VIN.n1245 VIN.n1244 3.1005
R2895 VIN.n1243 VIN.n1242 3.1005
R2896 VIN.n1239 VIN.n160 3.1005
R2897 VIN.n1238 VIN.n1237 3.1005
R2898 VIN.n1218 VIN.n1217 3.1005
R2899 VIN.n1215 VIN.n162 3.1005
R2900 VIN.n1214 VIN.n1213 3.1005
R2901 VIN.n1195 VIN.n1194 3.1005
R2902 VIN.n1192 VIN.n1191 3.1005
R2903 VIN.n1190 VIN.n165 3.1005
R2904 VIN.n1188 VIN.n1187 3.1005
R2905 VIN.n1185 VIN.n182 3.1005
R2906 VIN.n1182 VIN.n183 3.1005
R2907 VIN.n1180 VIN.n1179 3.1005
R2908 VIN.n1177 VIN.n200 3.1005
R2909 VIN.n1176 VIN.n1175 3.1005
R2910 VIN.n1173 VIN.n1172 3.1005
R2911 VIN.n1170 VIN.n1169 3.1005
R2912 VIN.n1168 VIN.n219 3.1005
R2913 VIN.n1166 VIN.n1165 3.1005
R2914 VIN.n1163 VIN.n236 3.1005
R2915 VIN.n1160 VIN.n237 3.1005
R2916 VIN.n1158 VIN.n1157 3.1005
R2917 VIN.n1155 VIN.n254 3.1005
R2918 VIN.n1154 VIN.n1153 3.1005
R2919 VIN.n1150 VIN.n1149 3.1005
R2920 VIN.n1147 VIN.n272 3.1005
R2921 VIN.n1146 VIN.n1145 3.1005
R2922 VIN.n1143 VIN.n1142 3.1005
R2923 VIN.n1141 VIN.n290 3.1005
R2924 VIN.n1138 VIN.n291 3.1005
R2925 VIN.n1136 VIN.n1135 3.1005
R2926 VIN.n1133 VIN.n308 3.1005
R2927 VIN.n1132 VIN.n1131 3.1005
R2928 VIN.n1128 VIN.n1127 3.1005
R2929 VIN.n1126 VIN.n326 3.1005
R2930 VIN.n1125 VIN.n1124 3.1005
R2931 VIN.n1122 VIN.n327 3.1005
R2932 VIN.n1118 VIN.n344 3.1005
R2933 VIN.n1117 VIN.n1116 3.1005
R2934 VIN.n364 VIN.n345 3.1005
R2935 VIN.n1113 VIN.n1112 3.1005
R2936 VIN.n1109 VIN.n1108 3.1005
R2937 VIN.n1106 VIN.n365 3.1005
R2938 VIN.n1105 VIN.n1104 3.1005
R2939 VIN.n1102 VIN.n382 3.1005
R2940 VIN.n1101 VIN.n1100 3.1005
R2941 VIN.n1080 VIN.n384 3.1005
R2942 VIN.n1079 VIN.n1078 3.1005
R2943 VIN.n1076 VIN.n385 3.1005
R2944 VIN.n1047 VIN.n1046 3.04812
R2945 VIN.n1045 VIN.n636 3.04812
R2946 VIN.n1073 VIN.n1072 2.74336
R2947 VIN.n1068 VIN.n437 2.74336
R2948 VIN.n1013 VIN.n816 2.74336
R2949 VIN.n1058 VIN.n536 2.4386
R2950 VIN.n997 VIN.n996 2.4386
R2951 VIN.n968 VIN.n967 2.24002
R2952 VIN.n975 VIN.n966 2.23989
R2953 VIN.n985 VIN.n984 2.17126
R2954 VIN.n1031 VIN.n1030 2.13383
R2955 VIN.n1030 VIN.n1029 2.13383
R2956 VIN.n1241 VIN.n1240 1.8598
R2957 VIN.n1055 VIN.n536 1.82907
R2958 VIN.n998 VIN.n997 1.82907
R2959 VIN.n975 VIN.n974 1.73585
R2960 VIN.n981 VIN.n980 1.71429
R2961 VIN.n974 VIN.n973 1.7055
R2962 VIN.n979 VIN.n978 1.7055
R2963 VIN.n977 VIN.n976 1.7055
R2964 VIN.n969 VIN.n965 1.7055
R2965 VIN.n1521 VIN.n1520 1.6005
R2966 VIN.n1314 VIN.n126 1.6005
R2967 VIN.n1545 VIN.n1544 1.5505
R2968 VIN.n1518 VIN.n42 1.5505
R2969 VIN.n1520 VIN.n1519 1.5505
R2970 VIN.n1524 VIN.n1523 1.5505
R2971 VIN.n1526 VIN.n1525 1.5505
R2972 VIN.n1528 VIN.n1527 1.5505
R2973 VIN.n1530 VIN.n1529 1.5505
R2974 VIN.n1407 VIN.n123 1.5505
R2975 VIN.n1405 VIN.n1404 1.5505
R2976 VIN.n127 VIN.n126 1.5505
R2977 VIN.n1335 VIN.n1334 1.5505
R2978 VIN.n1337 VIN.n1336 1.5505
R2979 VIN.n1338 VIN.n1275 1.5505
R2980 VIN.n1341 VIN.n1340 1.5505
R2981 VIN.n437 VIN.n403 1.52431
R2982 VIN.n820 VIN.n816 1.52431
R2983 VIN.n1043 VIN.n1042 1.52238
R2984 VIN.n986 VIN.n891 1.52238
R2985 VIN.n1042 VIN.n1041 1.5005
R2986 VIN.n639 VIN.n638 1.5005
R2987 VIN.n1036 VIN.n1035 1.5005
R2988 VIN.n1034 VIN.n1033 1.5005
R2989 VIN.n676 VIN.n675 1.5005
R2990 VIN.n1027 VIN.n1026 1.5005
R2991 VIN.n1025 VIN.n1024 1.5005
R2992 VIN.n713 VIN.n712 1.5005
R2993 VIN.n1019 VIN.n1018 1.5005
R2994 VIN.n1017 VIN.n1016 1.5005
R2995 VIN.n750 VIN.n749 1.5005
R2996 VIN.n1011 VIN.n1010 1.5005
R2997 VIN.n1009 VIN.n1008 1.5005
R2998 VIN.n819 VIN.n818 1.5005
R2999 VIN.n1003 VIN.n1002 1.5005
R3000 VIN.n1001 VIN.n1000 1.5005
R3001 VIN.n856 VIN.n855 1.5005
R3002 VIN.n994 VIN.n993 1.5005
R3003 VIN.n992 VIN.n991 1.5005
R3004 VIN.n892 VIN.n891 1.5005
R3005 VIN.n1048 VIN.n1047 1.21955
R3006 VIN.n640 VIN.n636 1.21955
R3007 VIN.n1066 VIN.n1065 0.914786
R3008 VIN.n783 VIN.n747 0.914786
R3009 VIN.n989 VIN.n925 0.914786
R3010 VIN.n980 VIN.n979 0.870088
R3011 VIN.n970 VIN.t2154 0.855479
R3012 VIN.n1114 VIN 0.824613
R3013 VIN.n1079 VIN.n385 0.802649
R3014 VIN.n1080 VIN.n1079 0.802649
R3015 VIN.n1102 VIN.n1101 0.802649
R3016 VIN.n1104 VIN.n1102 0.802649
R3017 VIN.n1109 VIN.n365 0.802649
R3018 VIN.n1117 VIN.n345 0.802649
R3019 VIN.n1118 VIN.n1117 0.802649
R3020 VIN.n1125 VIN.n327 0.802649
R3021 VIN.n1126 VIN.n1125 0.802649
R3022 VIN.n1127 VIN.n1126 0.802649
R3023 VIN.n1133 VIN.n1132 0.802649
R3024 VIN.n1135 VIN.n1133 0.802649
R3025 VIN.n1142 VIN.n1141 0.802649
R3026 VIN.n1147 VIN.n1146 0.802649
R3027 VIN.n1149 VIN.n1147 0.802649
R3028 VIN.n1155 VIN.n1154 0.802649
R3029 VIN.n1157 VIN.n1155 0.802649
R3030 VIN.n1165 VIN.n1163 0.802649
R3031 VIN.n1170 VIN.n219 0.802649
R3032 VIN.n1177 VIN.n1176 0.802649
R3033 VIN.n1179 VIN.n1177 0.802649
R3034 VIN.n1187 VIN.n1185 0.802649
R3035 VIN.n1192 VIN.n165 0.802649
R3036 VIN.n1215 VIN.n1214 0.802649
R3037 VIN.n1217 VIN.n1215 0.802649
R3038 VIN.n1239 VIN.n1238 0.802649
R3039 VIN.n1250 VIN.n141 0.802649
R3040 VIN.n1255 VIN.n1252 0.802649
R3041 VIN.n1255 VIN.n1254 0.802649
R3042 VIN.n1362 VIN.n1361 0.802649
R3043 VIN.n1364 VIN.n1362 0.802649
R3044 VIN.n1371 VIN.n1370 0.802649
R3045 VIN.n1375 VIN.n1374 0.802649
R3046 VIN.n1384 VIN.n1381 0.802649
R3047 VIN.n1384 VIN.n1383 0.802649
R3048 VIN.n1431 VIN.n1429 0.802649
R3049 VIN.n1436 VIN.n103 0.802649
R3050 VIN.n1459 VIN.n1458 0.802649
R3051 VIN.n1461 VIN.n1459 0.802649
R3052 VIN.n1483 VIN.n1482 0.802649
R3053 VIN.n1484 VIN.n1483 0.802649
R3054 VIN.n1492 VIN.n79 0.802649
R3055 VIN.n1497 VIN.n1494 0.802649
R3056 VIN.n1497 VIN.n1496 0.802649
R3057 VIN.n1566 VIN.n1565 0.802649
R3058 VIN.n1568 VIN.n1566 0.802649
R3059 VIN.n1575 VIN.n1573 0.802649
R3060 VIN.n1580 VIN.n19 0.802649
R3061 VIN.n1134 VIN.n291 0.77973
R3062 VIN.n1112 VIN.n1111 0.756812
R3063 VIN.n1146 VIN.n273 0.756812
R3064 VIN.n963 VIN.n960 0.7505
R3065 VIN.n1112 VIN.n1110 0.745352
R3066 VIN.n1140 VIN.n291 0.745352
R3067 VIN.n1185 VIN.n1184 0.745352
R3068 VIN.n1246 VIN.n1245 0.745352
R3069 VIN.n1429 VIN.n1428 0.745352
R3070 VIN.n1488 VIN.n1487 0.745352
R3071 VIN.n1104 VIN.n1103 0.733893
R3072 VIN.n1156 VIN.n237 0.710974
R3073 VIN.n1523 VIN.n1522 0.7045
R3074 VIN.n1334 VIN.n1333 0.7045
R3075 VIN.n1075 VIN.n1074 0.688056
R3076 VIN.n1164 VIN.n219 0.688056
R3077 VIN.n1176 VIN.n201 0.665137
R3078 VIN.n973 VIN.n972 0.660804
R3079 VIN.n983 VIN.n963 0.6505
R3080 VIN.n1178 VIN.n183 0.642219
R3081 VIN.n1081 VIN.n1080 0.63076
R3082 VIN.n1154 VIN.n255 0.63076
R3083 VIN.n1171 VIN.n1170 0.63076
R3084 VIN.n1375 VIN.n130 0.63076
R3085 VIN.n1581 VIN.n1580 0.63076
R3086 VIN.n1186 VIN.n165 0.6193
R3087 VIN.n1061 VIN.n1060 0.610024
R3088 VIN.n1022 VIN.n746 0.610024
R3089 VIN.n1214 VIN.n163 0.596382
R3090 VIN.n1582 VIN.n17 0.596382
R3091 VIN.n971 VIN.n970 0.595833
R3092 VIN.n972 VIN.n971 0.595833
R3093 VIN.n1575 VIN.n1574 0.573463
R3094 VIN.n1245 VIN.n159 0.550545
R3095 VIN.n1568 VIN.n1567 0.550545
R3096 VIN.n1252 VIN.n1251 0.527626
R3097 VIN.n1127 VIN.n309 0.516167
R3098 VIN.n1194 VIN.n1193 0.516167
R3099 VIN.n1438 VIN.n1437 0.516167
R3100 VIN.n1440 VIN.n70 0.50675
R3101 VIN.n1361 VIN.n137 0.504708
R3102 VIN.n1493 VIN.n1492 0.504708
R3103 VIN.n1120 VIN.n1119 0.493248
R3104 VIN.n1363 VIN.n134 0.481789
R3105 VIN.n1484 VIN.n97 0.481789
R3106 VIN.n1274 VIN.n1273 0.48175
R3107 VIN.n1374 VIN.n132 0.458871
R3108 VIN.n1461 VIN.n1460 0.458871
R3109 VIN.n1241 VIN.n1239 0.447411
R3110 VIN.n1381 VIN.n1380 0.435952
R3111 VIN.n1438 VIN.n101 0.435952
R3112 VIN.n58 VIN.n57 0.428625
R3113 VIN.n1382 VIN.n121 0.413034
R3114 VIN.n1431 VIN.n1430 0.413034
R3115 VIN.n1162 VIN.n237 0.401574
R3116 VIN.n1163 VIN.n1162 0.401574
R3117 VIN.n1369 VIN.n134 0.401574
R3118 VIN.n1370 VIN.n1369 0.401574
R3119 VIN.n1572 VIN.n37 0.401574
R3120 VIN.n1573 VIN.n1572 0.401574
R3121 VIN.n1383 VIN.n1382 0.390115
R3122 VIN.n1430 VIN.n103 0.390115
R3123 VIN.n1380 VIN.n1379 0.367197
R3124 VIN.n1458 VIN.n101 0.367197
R3125 VIN.n1410 VIN 0.363
R3126 VIN.n1242 VIN.n1241 0.355737
R3127 VIN.n1495 VIN.n40 0.355737
R3128 VIN.n1464 VIN.n73 0.3505
R3129 VIN.n80 VIN.n74 0.3505
R3130 VIN.n1516 VIN.n1515 0.3505
R3131 VIN.n1547 VIN.n1546 0.3505
R3132 VIN.n1312 VIN.n1311 0.3505
R3133 VIN.n1403 VIN.n1402 0.3505
R3134 VIN.n1295 VIN.n1294 0.3505
R3135 VIN.n1343 VIN.n1342 0.3505
R3136 VIN.n1371 VIN.n132 0.344278
R3137 VIN.n1364 VIN.n1363 0.321359
R3138 VIN.n1487 VIN.n97 0.321359
R3139 VIN.n1053 VIN.n1052 0.305262
R3140 VIN.n1038 VIN.n673 0.305262
R3141 VIN.n1494 VIN.n1493 0.298441
R3142 VIN.n1120 VIN.n1118 0.286982
R3143 VIN.n1132 VIN.n309 0.286982
R3144 VIN.n1193 VIN.n1192 0.286982
R3145 VIN.n1216 VIN.n161 0.286982
R3146 VIN.n1238 VIN.n161 0.286982
R3147 VIN.n1437 VIN.n1436 0.286982
R3148 VIN.n1482 VIN.n99 0.286982
R3149 VIN.n1251 VIN.n1250 0.275522
R3150 VIN.n1565 VIN.n40 0.275522
R3151 VIN.n15 VIN.n14 0.261438
R3152 VIN.n14 VIN.n13 0.261438
R3153 VIN.n13 VIN.n12 0.261438
R3154 VIN.n12 VIN.n11 0.261438
R3155 VIN.n11 VIN.n10 0.261438
R3156 VIN.n10 VIN.n9 0.261438
R3157 VIN.n9 VIN.n8 0.261438
R3158 VIN.n8 VIN.n7 0.261438
R3159 VIN.n7 VIN.n6 0.261438
R3160 VIN.n6 VIN.n5 0.261438
R3161 VIN.n5 VIN.n4 0.261438
R3162 VIN.n4 VIN.n3 0.261438
R3163 VIN.n3 VIN.n2 0.261438
R3164 VIN.n2 VIN.n1 0.261438
R3165 VIN.n1 VIN.n0 0.261438
R3166 VIN.n35 VIN.n34 0.261438
R3167 VIN.n34 VIN.n33 0.261438
R3168 VIN.n33 VIN.n32 0.261438
R3169 VIN.n32 VIN.n31 0.261438
R3170 VIN.n31 VIN.n30 0.261438
R3171 VIN.n30 VIN.n29 0.261438
R3172 VIN.n29 VIN.n28 0.261438
R3173 VIN.n28 VIN.n27 0.261438
R3174 VIN.n27 VIN.n26 0.261438
R3175 VIN.n26 VIN.n25 0.261438
R3176 VIN.n25 VIN.n24 0.261438
R3177 VIN.n24 VIN.n23 0.261438
R3178 VIN.n23 VIN.n22 0.261438
R3179 VIN.n22 VIN.n21 0.261438
R3180 VIN.n21 VIN.n20 0.261438
R3181 VIN.n43 VIN.n38 0.261438
R3182 VIN.n44 VIN.n43 0.261438
R3183 VIN.n45 VIN.n44 0.261438
R3184 VIN.n46 VIN.n45 0.261438
R3185 VIN.n47 VIN.n46 0.261438
R3186 VIN.n48 VIN.n47 0.261438
R3187 VIN.n49 VIN.n48 0.261438
R3188 VIN.n50 VIN.n49 0.261438
R3189 VIN.n51 VIN.n50 0.261438
R3190 VIN.n52 VIN.n51 0.261438
R3191 VIN.n53 VIN.n52 0.261438
R3192 VIN.n54 VIN.n53 0.261438
R3193 VIN.n55 VIN.n54 0.261438
R3194 VIN.n56 VIN.n55 0.261438
R3195 VIN.n57 VIN.n56 0.261438
R3196 VIN.n1479 VIN.n1478 0.261438
R3197 VIN.n1478 VIN.n1477 0.261438
R3198 VIN.n1477 VIN.n1476 0.261438
R3199 VIN.n1476 VIN.n1475 0.261438
R3200 VIN.n1475 VIN.n1474 0.261438
R3201 VIN.n1474 VIN.n1473 0.261438
R3202 VIN.n1473 VIN.n1472 0.261438
R3203 VIN.n1472 VIN.n1471 0.261438
R3204 VIN.n1471 VIN.n1470 0.261438
R3205 VIN.n1470 VIN.n1469 0.261438
R3206 VIN.n1469 VIN.n1468 0.261438
R3207 VIN.n1468 VIN.n1467 0.261438
R3208 VIN.n1467 VIN.n1466 0.261438
R3209 VIN.n1466 VIN.n1465 0.261438
R3210 VIN.n1465 VIN.n1464 0.261438
R3211 VIN.n95 VIN.n94 0.261438
R3212 VIN.n94 VIN.n93 0.261438
R3213 VIN.n93 VIN.n92 0.261438
R3214 VIN.n92 VIN.n91 0.261438
R3215 VIN.n91 VIN.n90 0.261438
R3216 VIN.n90 VIN.n89 0.261438
R3217 VIN.n89 VIN.n88 0.261438
R3218 VIN.n88 VIN.n87 0.261438
R3219 VIN.n87 VIN.n86 0.261438
R3220 VIN.n86 VIN.n85 0.261438
R3221 VIN.n85 VIN.n84 0.261438
R3222 VIN.n84 VIN.n83 0.261438
R3223 VIN.n83 VIN.n82 0.261438
R3224 VIN.n82 VIN.n81 0.261438
R3225 VIN.n81 VIN.n80 0.261438
R3226 VIN.n1501 VIN.n1500 0.261438
R3227 VIN.n1502 VIN.n1501 0.261438
R3228 VIN.n1503 VIN.n1502 0.261438
R3229 VIN.n1504 VIN.n1503 0.261438
R3230 VIN.n1505 VIN.n1504 0.261438
R3231 VIN.n1506 VIN.n1505 0.261438
R3232 VIN.n1507 VIN.n1506 0.261438
R3233 VIN.n1508 VIN.n1507 0.261438
R3234 VIN.n1509 VIN.n1508 0.261438
R3235 VIN.n1510 VIN.n1509 0.261438
R3236 VIN.n1511 VIN.n1510 0.261438
R3237 VIN.n1512 VIN.n1511 0.261438
R3238 VIN.n1513 VIN.n1512 0.261438
R3239 VIN.n1514 VIN.n1513 0.261438
R3240 VIN.n1515 VIN.n1514 0.261438
R3241 VIN.n1562 VIN.n1561 0.261438
R3242 VIN.n1561 VIN.n1560 0.261438
R3243 VIN.n1560 VIN.n1559 0.261438
R3244 VIN.n1559 VIN.n1558 0.261438
R3245 VIN.n1558 VIN.n1557 0.261438
R3246 VIN.n1557 VIN.n1556 0.261438
R3247 VIN.n1556 VIN.n1555 0.261438
R3248 VIN.n1555 VIN.n1554 0.261438
R3249 VIN.n1554 VIN.n1553 0.261438
R3250 VIN.n1553 VIN.n1552 0.261438
R3251 VIN.n1552 VIN.n1551 0.261438
R3252 VIN.n1551 VIN.n1550 0.261438
R3253 VIN.n1550 VIN.n1549 0.261438
R3254 VIN.n1549 VIN.n1548 0.261438
R3255 VIN.n1548 VIN.n1547 0.261438
R3256 VIN.n1455 VIN.n1454 0.261438
R3257 VIN.n1454 VIN.n1453 0.261438
R3258 VIN.n1453 VIN.n1452 0.261438
R3259 VIN.n1452 VIN.n1451 0.261438
R3260 VIN.n1451 VIN.n1450 0.261438
R3261 VIN.n1450 VIN.n1449 0.261438
R3262 VIN.n1449 VIN.n1448 0.261438
R3263 VIN.n1448 VIN.n1447 0.261438
R3264 VIN.n1447 VIN.n1446 0.261438
R3265 VIN.n1446 VIN.n1445 0.261438
R3266 VIN.n1445 VIN.n1444 0.261438
R3267 VIN.n1444 VIN.n1443 0.261438
R3268 VIN.n1443 VIN.n1442 0.261438
R3269 VIN.n1442 VIN.n1441 0.261438
R3270 VIN.n1441 VIN.n1440 0.261438
R3271 VIN.n119 VIN.n118 0.261438
R3272 VIN.n118 VIN.n117 0.261438
R3273 VIN.n117 VIN.n116 0.261438
R3274 VIN.n116 VIN.n115 0.261438
R3275 VIN.n115 VIN.n114 0.261438
R3276 VIN.n114 VIN.n113 0.261438
R3277 VIN.n113 VIN.n112 0.261438
R3278 VIN.n112 VIN.n111 0.261438
R3279 VIN.n111 VIN.n110 0.261438
R3280 VIN.n110 VIN.n109 0.261438
R3281 VIN.n109 VIN.n108 0.261438
R3282 VIN.n108 VIN.n107 0.261438
R3283 VIN.n107 VIN.n106 0.261438
R3284 VIN.n106 VIN.n105 0.261438
R3285 VIN.n105 VIN.n104 0.261438
R3286 VIN.n1297 VIN.n1296 0.261438
R3287 VIN.n1298 VIN.n1297 0.261438
R3288 VIN.n1299 VIN.n1298 0.261438
R3289 VIN.n1300 VIN.n1299 0.261438
R3290 VIN.n1301 VIN.n1300 0.261438
R3291 VIN.n1302 VIN.n1301 0.261438
R3292 VIN.n1303 VIN.n1302 0.261438
R3293 VIN.n1304 VIN.n1303 0.261438
R3294 VIN.n1305 VIN.n1304 0.261438
R3295 VIN.n1306 VIN.n1305 0.261438
R3296 VIN.n1307 VIN.n1306 0.261438
R3297 VIN.n1308 VIN.n1307 0.261438
R3298 VIN.n1309 VIN.n1308 0.261438
R3299 VIN.n1310 VIN.n1309 0.261438
R3300 VIN.n1311 VIN.n1310 0.261438
R3301 VIN.n1388 VIN.n1387 0.261438
R3302 VIN.n1389 VIN.n1388 0.261438
R3303 VIN.n1390 VIN.n1389 0.261438
R3304 VIN.n1391 VIN.n1390 0.261438
R3305 VIN.n1392 VIN.n1391 0.261438
R3306 VIN.n1393 VIN.n1392 0.261438
R3307 VIN.n1394 VIN.n1393 0.261438
R3308 VIN.n1395 VIN.n1394 0.261438
R3309 VIN.n1396 VIN.n1395 0.261438
R3310 VIN.n1397 VIN.n1396 0.261438
R3311 VIN.n1398 VIN.n1397 0.261438
R3312 VIN.n1399 VIN.n1398 0.261438
R3313 VIN.n1400 VIN.n1399 0.261438
R3314 VIN.n1401 VIN.n1400 0.261438
R3315 VIN.n1402 VIN.n1401 0.261438
R3316 VIN.n1425 VIN.n1424 0.261438
R3317 VIN.n1424 VIN.n1423 0.261438
R3318 VIN.n1423 VIN.n1422 0.261438
R3319 VIN.n1422 VIN.n1421 0.261438
R3320 VIN.n1421 VIN.n1420 0.261438
R3321 VIN.n1420 VIN.n1419 0.261438
R3322 VIN.n1419 VIN.n1418 0.261438
R3323 VIN.n1418 VIN.n1417 0.261438
R3324 VIN.n1417 VIN.n1416 0.261438
R3325 VIN.n1416 VIN.n1415 0.261438
R3326 VIN.n1415 VIN.n1414 0.261438
R3327 VIN.n1414 VIN.n1413 0.261438
R3328 VIN.n1413 VIN.n1412 0.261438
R3329 VIN.n1412 VIN.n1411 0.261438
R3330 VIN.n1411 VIN.n1410 0.261438
R3331 VIN.n1280 VIN.n135 0.261438
R3332 VIN.n1281 VIN.n1280 0.261438
R3333 VIN.n1282 VIN.n1281 0.261438
R3334 VIN.n1283 VIN.n1282 0.261438
R3335 VIN.n1284 VIN.n1283 0.261438
R3336 VIN.n1285 VIN.n1284 0.261438
R3337 VIN.n1286 VIN.n1285 0.261438
R3338 VIN.n1287 VIN.n1286 0.261438
R3339 VIN.n1288 VIN.n1287 0.261438
R3340 VIN.n1289 VIN.n1288 0.261438
R3341 VIN.n1290 VIN.n1289 0.261438
R3342 VIN.n1291 VIN.n1290 0.261438
R3343 VIN.n1292 VIN.n1291 0.261438
R3344 VIN.n1293 VIN.n1292 0.261438
R3345 VIN.n1294 VIN.n1293 0.261438
R3346 VIN.n1358 VIN.n1357 0.261438
R3347 VIN.n1357 VIN.n1356 0.261438
R3348 VIN.n1356 VIN.n1355 0.261438
R3349 VIN.n1355 VIN.n1354 0.261438
R3350 VIN.n1354 VIN.n1353 0.261438
R3351 VIN.n1353 VIN.n1352 0.261438
R3352 VIN.n1352 VIN.n1351 0.261438
R3353 VIN.n1351 VIN.n1350 0.261438
R3354 VIN.n1350 VIN.n1349 0.261438
R3355 VIN.n1349 VIN.n1348 0.261438
R3356 VIN.n1348 VIN.n1347 0.261438
R3357 VIN.n1347 VIN.n1346 0.261438
R3358 VIN.n1346 VIN.n1345 0.261438
R3359 VIN.n1345 VIN.n1344 0.261438
R3360 VIN.n1344 VIN.n1343 0.261438
R3361 VIN.n1259 VIN.n1258 0.261438
R3362 VIN.n1260 VIN.n1259 0.261438
R3363 VIN.n1261 VIN.n1260 0.261438
R3364 VIN.n1262 VIN.n1261 0.261438
R3365 VIN.n1263 VIN.n1262 0.261438
R3366 VIN.n1264 VIN.n1263 0.261438
R3367 VIN.n1265 VIN.n1264 0.261438
R3368 VIN.n1266 VIN.n1265 0.261438
R3369 VIN.n1267 VIN.n1266 0.261438
R3370 VIN.n1268 VIN.n1267 0.261438
R3371 VIN.n1269 VIN.n1268 0.261438
R3372 VIN.n1270 VIN.n1269 0.261438
R3373 VIN.n1271 VIN.n1270 0.261438
R3374 VIN.n1272 VIN.n1271 0.261438
R3375 VIN.n1273 VIN.n1272 0.261438
R3376 VIN.n157 VIN.n156 0.261438
R3377 VIN.n156 VIN.n155 0.261438
R3378 VIN.n155 VIN.n154 0.261438
R3379 VIN.n154 VIN.n153 0.261438
R3380 VIN.n153 VIN.n152 0.261438
R3381 VIN.n152 VIN.n151 0.261438
R3382 VIN.n151 VIN.n150 0.261438
R3383 VIN.n150 VIN.n149 0.261438
R3384 VIN.n149 VIN.n148 0.261438
R3385 VIN.n148 VIN.n147 0.261438
R3386 VIN.n147 VIN.n146 0.261438
R3387 VIN.n146 VIN.n145 0.261438
R3388 VIN.n145 VIN.n144 0.261438
R3389 VIN.n144 VIN.n143 0.261438
R3390 VIN.n143 VIN.n142 0.261438
R3391 VIN.n1235 VIN.n1234 0.261438
R3392 VIN.n1234 VIN.n1233 0.261438
R3393 VIN.n1233 VIN.n1232 0.261438
R3394 VIN.n1232 VIN.n1231 0.261438
R3395 VIN.n1231 VIN.n1230 0.261438
R3396 VIN.n1230 VIN.n1229 0.261438
R3397 VIN.n1229 VIN.n1228 0.261438
R3398 VIN.n1228 VIN.n1227 0.261438
R3399 VIN.n1227 VIN.n1226 0.261438
R3400 VIN.n1226 VIN.n1225 0.261438
R3401 VIN.n1225 VIN.n1224 0.261438
R3402 VIN.n1224 VIN.n1223 0.261438
R3403 VIN.n1223 VIN.n1222 0.261438
R3404 VIN.n1222 VIN.n1221 0.261438
R3405 VIN.n1221 VIN.n1220 0.261438
R3406 VIN.n1211 VIN.n1210 0.261438
R3407 VIN.n1210 VIN.n1209 0.261438
R3408 VIN.n1209 VIN.n1208 0.261438
R3409 VIN.n1208 VIN.n1207 0.261438
R3410 VIN.n1207 VIN.n1206 0.261438
R3411 VIN.n1206 VIN.n1205 0.261438
R3412 VIN.n1205 VIN.n1204 0.261438
R3413 VIN.n1204 VIN.n1203 0.261438
R3414 VIN.n1203 VIN.n1202 0.261438
R3415 VIN.n1202 VIN.n1201 0.261438
R3416 VIN.n1201 VIN.n1200 0.261438
R3417 VIN.n1200 VIN.n1199 0.261438
R3418 VIN.n1199 VIN.n1198 0.261438
R3419 VIN.n1198 VIN.n1197 0.261438
R3420 VIN.n1197 VIN.n1196 0.261438
R3421 VIN.n181 VIN.n180 0.261438
R3422 VIN.n180 VIN.n179 0.261438
R3423 VIN.n179 VIN.n178 0.261438
R3424 VIN.n178 VIN.n177 0.261438
R3425 VIN.n177 VIN.n176 0.261438
R3426 VIN.n176 VIN.n175 0.261438
R3427 VIN.n175 VIN.n174 0.261438
R3428 VIN.n174 VIN.n173 0.261438
R3429 VIN.n173 VIN.n172 0.261438
R3430 VIN.n172 VIN.n171 0.261438
R3431 VIN.n171 VIN.n170 0.261438
R3432 VIN.n170 VIN.n169 0.261438
R3433 VIN.n169 VIN.n168 0.261438
R3434 VIN.n168 VIN.n167 0.261438
R3435 VIN.n167 VIN.n166 0.261438
R3436 VIN.n199 VIN.n198 0.261438
R3437 VIN.n198 VIN.n197 0.261438
R3438 VIN.n197 VIN.n196 0.261438
R3439 VIN.n196 VIN.n195 0.261438
R3440 VIN.n195 VIN.n194 0.261438
R3441 VIN.n194 VIN.n193 0.261438
R3442 VIN.n193 VIN.n192 0.261438
R3443 VIN.n192 VIN.n191 0.261438
R3444 VIN.n191 VIN.n190 0.261438
R3445 VIN.n190 VIN.n189 0.261438
R3446 VIN.n189 VIN.n188 0.261438
R3447 VIN.n188 VIN.n187 0.261438
R3448 VIN.n187 VIN.n186 0.261438
R3449 VIN.n186 VIN.n185 0.261438
R3450 VIN.n185 VIN.n184 0.261438
R3451 VIN.n217 VIN.n216 0.261438
R3452 VIN.n216 VIN.n215 0.261438
R3453 VIN.n215 VIN.n214 0.261438
R3454 VIN.n214 VIN.n213 0.261438
R3455 VIN.n213 VIN.n212 0.261438
R3456 VIN.n212 VIN.n211 0.261438
R3457 VIN.n211 VIN.n210 0.261438
R3458 VIN.n210 VIN.n209 0.261438
R3459 VIN.n209 VIN.n208 0.261438
R3460 VIN.n208 VIN.n207 0.261438
R3461 VIN.n207 VIN.n206 0.261438
R3462 VIN.n206 VIN.n205 0.261438
R3463 VIN.n205 VIN.n204 0.261438
R3464 VIN.n204 VIN.n203 0.261438
R3465 VIN.n203 VIN.n202 0.261438
R3466 VIN.n235 VIN.n234 0.261438
R3467 VIN.n234 VIN.n233 0.261438
R3468 VIN.n233 VIN.n232 0.261438
R3469 VIN.n232 VIN.n231 0.261438
R3470 VIN.n231 VIN.n230 0.261438
R3471 VIN.n230 VIN.n229 0.261438
R3472 VIN.n229 VIN.n228 0.261438
R3473 VIN.n228 VIN.n227 0.261438
R3474 VIN.n227 VIN.n226 0.261438
R3475 VIN.n226 VIN.n225 0.261438
R3476 VIN.n225 VIN.n224 0.261438
R3477 VIN.n224 VIN.n223 0.261438
R3478 VIN.n223 VIN.n222 0.261438
R3479 VIN.n222 VIN.n221 0.261438
R3480 VIN.n221 VIN.n220 0.261438
R3481 VIN.n253 VIN.n252 0.261438
R3482 VIN.n252 VIN.n251 0.261438
R3483 VIN.n251 VIN.n250 0.261438
R3484 VIN.n250 VIN.n249 0.261438
R3485 VIN.n249 VIN.n248 0.261438
R3486 VIN.n248 VIN.n247 0.261438
R3487 VIN.n247 VIN.n246 0.261438
R3488 VIN.n246 VIN.n245 0.261438
R3489 VIN.n245 VIN.n244 0.261438
R3490 VIN.n244 VIN.n243 0.261438
R3491 VIN.n243 VIN.n242 0.261438
R3492 VIN.n242 VIN.n241 0.261438
R3493 VIN.n241 VIN.n240 0.261438
R3494 VIN.n240 VIN.n239 0.261438
R3495 VIN.n239 VIN.n238 0.261438
R3496 VIN.n271 VIN.n270 0.261438
R3497 VIN.n270 VIN.n269 0.261438
R3498 VIN.n269 VIN.n268 0.261438
R3499 VIN.n268 VIN.n267 0.261438
R3500 VIN.n267 VIN.n266 0.261438
R3501 VIN.n266 VIN.n265 0.261438
R3502 VIN.n265 VIN.n264 0.261438
R3503 VIN.n264 VIN.n263 0.261438
R3504 VIN.n263 VIN.n262 0.261438
R3505 VIN.n262 VIN.n261 0.261438
R3506 VIN.n261 VIN.n260 0.261438
R3507 VIN.n260 VIN.n259 0.261438
R3508 VIN.n259 VIN.n258 0.261438
R3509 VIN.n258 VIN.n257 0.261438
R3510 VIN.n257 VIN.n256 0.261438
R3511 VIN.n289 VIN.n288 0.261438
R3512 VIN.n288 VIN.n287 0.261438
R3513 VIN.n287 VIN.n286 0.261438
R3514 VIN.n286 VIN.n285 0.261438
R3515 VIN.n285 VIN.n284 0.261438
R3516 VIN.n284 VIN.n283 0.261438
R3517 VIN.n283 VIN.n282 0.261438
R3518 VIN.n282 VIN.n281 0.261438
R3519 VIN.n281 VIN.n280 0.261438
R3520 VIN.n280 VIN.n279 0.261438
R3521 VIN.n279 VIN.n278 0.261438
R3522 VIN.n278 VIN.n277 0.261438
R3523 VIN.n277 VIN.n276 0.261438
R3524 VIN.n276 VIN.n275 0.261438
R3525 VIN.n275 VIN.n274 0.261438
R3526 VIN.n307 VIN.n306 0.261438
R3527 VIN.n306 VIN.n305 0.261438
R3528 VIN.n305 VIN.n304 0.261438
R3529 VIN.n304 VIN.n303 0.261438
R3530 VIN.n303 VIN.n302 0.261438
R3531 VIN.n302 VIN.n301 0.261438
R3532 VIN.n301 VIN.n300 0.261438
R3533 VIN.n300 VIN.n299 0.261438
R3534 VIN.n299 VIN.n298 0.261438
R3535 VIN.n298 VIN.n297 0.261438
R3536 VIN.n297 VIN.n296 0.261438
R3537 VIN.n296 VIN.n295 0.261438
R3538 VIN.n295 VIN.n294 0.261438
R3539 VIN.n294 VIN.n293 0.261438
R3540 VIN.n293 VIN.n292 0.261438
R3541 VIN.n325 VIN.n324 0.261438
R3542 VIN.n324 VIN.n323 0.261438
R3543 VIN.n323 VIN.n322 0.261438
R3544 VIN.n322 VIN.n321 0.261438
R3545 VIN.n321 VIN.n320 0.261438
R3546 VIN.n320 VIN.n319 0.261438
R3547 VIN.n319 VIN.n318 0.261438
R3548 VIN.n318 VIN.n317 0.261438
R3549 VIN.n317 VIN.n316 0.261438
R3550 VIN.n316 VIN.n315 0.261438
R3551 VIN.n315 VIN.n314 0.261438
R3552 VIN.n314 VIN.n313 0.261438
R3553 VIN.n313 VIN.n312 0.261438
R3554 VIN.n312 VIN.n311 0.261438
R3555 VIN.n311 VIN.n310 0.261438
R3556 VIN.n343 VIN.n342 0.261438
R3557 VIN.n342 VIN.n341 0.261438
R3558 VIN.n341 VIN.n340 0.261438
R3559 VIN.n340 VIN.n339 0.261438
R3560 VIN.n339 VIN.n338 0.261438
R3561 VIN.n338 VIN.n337 0.261438
R3562 VIN.n337 VIN.n336 0.261438
R3563 VIN.n336 VIN.n335 0.261438
R3564 VIN.n335 VIN.n334 0.261438
R3565 VIN.n334 VIN.n333 0.261438
R3566 VIN.n333 VIN.n332 0.261438
R3567 VIN.n332 VIN.n331 0.261438
R3568 VIN.n331 VIN.n330 0.261438
R3569 VIN.n330 VIN.n329 0.261438
R3570 VIN.n329 VIN.n328 0.261438
R3571 VIN.n361 VIN.n360 0.261438
R3572 VIN.n360 VIN.n359 0.261438
R3573 VIN.n359 VIN.n358 0.261438
R3574 VIN.n358 VIN.n357 0.261438
R3575 VIN.n357 VIN.n356 0.261438
R3576 VIN.n356 VIN.n355 0.261438
R3577 VIN.n355 VIN.n354 0.261438
R3578 VIN.n354 VIN.n353 0.261438
R3579 VIN.n353 VIN.n352 0.261438
R3580 VIN.n352 VIN.n351 0.261438
R3581 VIN.n351 VIN.n350 0.261438
R3582 VIN.n350 VIN.n349 0.261438
R3583 VIN.n349 VIN.n348 0.261438
R3584 VIN.n348 VIN.n347 0.261438
R3585 VIN.n347 VIN.n346 0.261438
R3586 VIN.n381 VIN.n380 0.261438
R3587 VIN.n380 VIN.n379 0.261438
R3588 VIN.n379 VIN.n378 0.261438
R3589 VIN.n378 VIN.n377 0.261438
R3590 VIN.n377 VIN.n376 0.261438
R3591 VIN.n376 VIN.n375 0.261438
R3592 VIN.n375 VIN.n374 0.261438
R3593 VIN.n374 VIN.n373 0.261438
R3594 VIN.n373 VIN.n372 0.261438
R3595 VIN.n372 VIN.n371 0.261438
R3596 VIN.n371 VIN.n370 0.261438
R3597 VIN.n370 VIN.n369 0.261438
R3598 VIN.n369 VIN.n368 0.261438
R3599 VIN.n368 VIN.n367 0.261438
R3600 VIN.n367 VIN.n366 0.261438
R3601 VIN.n1098 VIN.n1097 0.261438
R3602 VIN.n1097 VIN.n1096 0.261438
R3603 VIN.n1096 VIN.n1095 0.261438
R3604 VIN.n1095 VIN.n1094 0.261438
R3605 VIN.n1094 VIN.n1093 0.261438
R3606 VIN.n1093 VIN.n1092 0.261438
R3607 VIN.n1092 VIN.n1091 0.261438
R3608 VIN.n1091 VIN.n1090 0.261438
R3609 VIN.n1090 VIN.n1089 0.261438
R3610 VIN.n1089 VIN.n1088 0.261438
R3611 VIN.n1088 VIN.n1087 0.261438
R3612 VIN.n1087 VIN.n1086 0.261438
R3613 VIN.n1086 VIN.n1085 0.261438
R3614 VIN.n1085 VIN.n1084 0.261438
R3615 VIN.n1084 VIN.n1083 0.261438
R3616 VIN.n401 VIN.n400 0.261438
R3617 VIN.n400 VIN.n399 0.261438
R3618 VIN.n399 VIN.n398 0.261438
R3619 VIN.n398 VIN.n397 0.261438
R3620 VIN.n397 VIN.n396 0.261438
R3621 VIN.n396 VIN.n395 0.261438
R3622 VIN.n395 VIN.n394 0.261438
R3623 VIN.n394 VIN.n393 0.261438
R3624 VIN.n393 VIN.n392 0.261438
R3625 VIN.n392 VIN.n391 0.261438
R3626 VIN.n391 VIN.n390 0.261438
R3627 VIN.n390 VIN.n389 0.261438
R3628 VIN.n389 VIN.n388 0.261438
R3629 VIN.n388 VIN.n387 0.261438
R3630 VIN.n387 VIN.n386 0.261438
R3631 VIN.n972 VIN.t2155 0.260146
R3632 VIN.n971 VIN.t2152 0.260146
R3633 VIN.n970 VIN.t2153 0.260146
R3634 VIN.n1242 VIN.n159 0.252604
R3635 VIN.n1567 VIN.n37 0.252604
R3636 VIN.n1217 VIN.n1216 0.229685
R3637 VIN.n1574 VIN.n19 0.229685
R3638 VIN.n1194 VIN.n163 0.206767
R3639 VIN.n1585 VIN.n17 0.206767
R3640 VIN.n1187 VIN.n1186 0.183848
R3641 VIN.n1172 VIN.n1171 0.172389
R3642 VIN.n1254 VIN.n1253 0.172389
R3643 VIN.n1379 VIN.n130 0.172389
R3644 VIN.n1496 VIN.n1495 0.172389
R3645 VIN.n1582 VIN.n1581 0.172389
R3646 VIN.n1179 VIN.n1178 0.16093
R3647 VIN.n16 VIN.n15 0.155187
R3648 VIN.n1578 VIN.n35 0.155187
R3649 VIN.n1571 VIN.n38 0.155187
R3650 VIN.n1480 VIN.n1479 0.155187
R3651 VIN.n96 VIN.n95 0.155187
R3652 VIN.n1500 VIN.n1499 0.155187
R3653 VIN.n1563 VIN.n1562 0.155187
R3654 VIN.n1456 VIN.n1455 0.155187
R3655 VIN.n1434 VIN.n119 0.155187
R3656 VIN.n1296 VIN.n131 0.155187
R3657 VIN.n1387 VIN.n1386 0.155187
R3658 VIN.n1426 VIN.n1425 0.155187
R3659 VIN.n1367 VIN.n135 0.155187
R3660 VIN.n1359 VIN.n1358 0.155187
R3661 VIN.n1258 VIN.n1257 0.155187
R3662 VIN.n158 VIN.n157 0.155187
R3663 VIN.n1236 VIN.n1235 0.155187
R3664 VIN.n1212 VIN.n1211 0.155187
R3665 VIN.n1189 VIN.n181 0.155187
R3666 VIN.n1181 VIN.n199 0.155187
R3667 VIN.n1174 VIN.n217 0.155187
R3668 VIN.n1167 VIN.n235 0.155187
R3669 VIN.n1159 VIN.n253 0.155187
R3670 VIN.n1152 VIN.n271 0.155187
R3671 VIN.n1144 VIN.n289 0.155187
R3672 VIN.n1137 VIN.n307 0.155187
R3673 VIN.n1130 VIN.n325 0.155187
R3674 VIN.n1123 VIN.n343 0.155187
R3675 VIN.n362 VIN.n361 0.155187
R3676 VIN.n1107 VIN.n381 0.155187
R3677 VIN.n1099 VIN.n1098 0.155187
R3678 VIN.n1077 VIN.n401 0.155187
R3679 VIN.n1525 VIN.n1524 0.14425
R3680 VIN.n1336 VIN.n1335 0.14425
R3681 VIN.n1172 VIN.n201 0.138011
R3682 VIN.n1529 VIN.n1528 0.138
R3683 VIN.n1519 VIN.n42 0.138
R3684 VIN.n1545 VIN.n59 0.138
R3685 VIN.n1404 VIN.n127 0.138
R3686 VIN.n1409 VIN.n123 0.138
R3687 VIN.n1341 VIN.n1275 0.138
R3688 VIN.n1295 VIN.n1275 0.13175
R3689 VIN.n1342 VIN.n1274 0.13175
R3690 VIN.n1581 VIN.n18 0.129667
R3691 VIN.n1572 VIN.n1571 0.129667
R3692 VIN.n1495 VIN.n41 0.129667
R3693 VIN.n1489 VIN.n1488 0.129667
R3694 VIN.n1463 VIN.n99 0.129667
R3695 VIN.n1437 VIN.n102 0.129667
R3696 VIN.n1428 VIN.n1427 0.129667
R3697 VIN.n1377 VIN.n130 0.129667
R3698 VIN.n1369 VIN.n1368 0.129667
R3699 VIN.n1253 VIN.n138 0.129667
R3700 VIN.n1247 VIN.n1246 0.129667
R3701 VIN.n1219 VIN.n161 0.129667
R3702 VIN.n1193 VIN.n164 0.129667
R3703 VIN.n1184 VIN.n1183 0.129667
R3704 VIN.n1171 VIN.n218 0.129667
R3705 VIN.n1162 VIN.n1161 0.129667
R3706 VIN.n1151 VIN.n255 0.129667
R3707 VIN.n1140 VIN.n1139 0.129667
R3708 VIN.n1129 VIN.n309 0.129667
R3709 VIN.n1121 VIN.n1120 0.129667
R3710 VIN.n1110 VIN.n363 0.129667
R3711 VIN.n1082 VIN.n1081 0.129667
R3712 VIN.n1253 VIN.n137 0.126552
R3713 VIN.n73 VIN.n70 0.11925
R3714 VIN.n1074 VIN.n385 0.115093
R3715 VIN.n1165 VIN.n1164 0.115093
R3716 VIN.n1528 VIN.n74 0.10675
R3717 VIN.n1335 VIN.n1312 0.10675
R3718 VIN.n1148 VIN.n255 0.103633
R3719 VIN.n1404 VIN.n1403 0.09425
R3720 VIN.n1101 VIN.n383 0.0921741
R3721 VIN.n1157 VIN.n1156 0.0921741
R3722 VIN.n1115 VIN.n1114 0.0857032
R3723 VIN.n1114 VIN.n1113 0.0853755
R3724 VIN.n1524 VIN.n1516 0.08175
R3725 VIN.n1081 VIN.n383 0.0807149
R3726 VIN.n1103 VIN.n365 0.0692556
R3727 VIN.n1149 VIN.n1148 0.0692556
R3728 VIN.n1546 VIN.n42 0.06925
R3729 VIN.n1546 VIN.n1545 0.06925
R3730 VIN VIN.n1409 0.06925
R3731 VIN.n1110 VIN.n1109 0.0577963
R3732 VIN.n1141 VIN.n1140 0.0577963
R3733 VIN.n1184 VIN.n183 0.0577963
R3734 VIN.n1246 VIN.n141 0.0577963
R3735 VIN.n1428 VIN.n121 0.0577963
R3736 VIN.n1460 VIN.n99 0.0577963
R3737 VIN.n1488 VIN.n79 0.0577963
R3738 VIN.n1519 VIN.n1516 0.05675
R3739 VIN.n58 VIN 0.0505
R3740 VIN.n1111 VIN.n345 0.0463371
R3741 VIN.n1142 VIN.n273 0.0463371
R3742 VIN.n1403 VIN.n123 0.04425
R3743 VIN.n1525 VIN.n74 0.038
R3744 VIN.n1312 VIN.n127 0.03175
R3745 VIN.n968 VIN.n965 0.0303042
R3746 VIN.n976 VIN.n975 0.0299118
R3747 VIN.n1071 VIN.n402 0.0253342
R3748 VIN.n1119 VIN.n327 0.0234185
R3749 VIN.n1135 VIN.n1134 0.0234185
R3750 VIN.n982 VIN.n966 0.0232113
R3751 VIN.n967 VIN.n966 0.0232113
R3752 VIN.n981 VIN.n968 0.0229512
R3753 VIN.n983 VIN.n965 0.0225588
R3754 VIN.n1042 VIN.n638 0.022375
R3755 VIN.n1035 VIN.n638 0.022375
R3756 VIN.n1035 VIN.n1034 0.022375
R3757 VIN.n1034 VIN.n675 0.022375
R3758 VIN.n1026 VIN.n675 0.022375
R3759 VIN.n1026 VIN.n1025 0.022375
R3760 VIN.n1025 VIN.n712 0.022375
R3761 VIN.n1018 VIN.n712 0.022375
R3762 VIN.n1018 VIN.n1017 0.022375
R3763 VIN.n1017 VIN.n749 0.022375
R3764 VIN.n1010 VIN.n749 0.022375
R3765 VIN.n1010 VIN.n1009 0.022375
R3766 VIN.n1009 VIN.n818 0.022375
R3767 VIN.n1002 VIN.n818 0.022375
R3768 VIN.n1002 VIN.n1001 0.022375
R3769 VIN.n1001 VIN.n855 0.022375
R3770 VIN.n993 VIN.n855 0.022375
R3771 VIN.n993 VIN.n992 0.022375
R3772 VIN.n992 VIN.n891 0.022375
R3773 VIN.n1071 VIN.n1070 0.0218415
R3774 VIN.n1070 VIN.n1069 0.0218415
R3775 VIN.n1069 VIN.n404 0.0218415
R3776 VIN.n1064 VIN.n404 0.0218415
R3777 VIN.n1064 VIN.n1063 0.0218415
R3778 VIN.n1063 VIN.n1062 0.0218415
R3779 VIN.n1062 VIN.n471 0.0218415
R3780 VIN.n1057 VIN.n471 0.0218415
R3781 VIN.n1057 VIN.n1056 0.0218415
R3782 VIN.n1056 VIN.n537 0.0218415
R3783 VIN.n1051 VIN.n537 0.0218415
R3784 VIN.n1051 VIN.n1050 0.0218415
R3785 VIN.n1050 VIN.n1049 0.0218415
R3786 VIN.n1049 VIN.n571 0.0218415
R3787 VIN.n1044 VIN.n571 0.0218415
R3788 VIN.n1044 VIN.n1043 0.0212317
R3789 VIN.n1041 VIN.n637 0.0212317
R3790 VIN.n1040 VIN.n639 0.0212317
R3791 VIN.n1037 VIN.n1036 0.0212317
R3792 VIN.n1033 VIN.n674 0.0212317
R3793 VIN.n1032 VIN.n676 0.0212317
R3794 VIN.n1028 VIN.n1027 0.0212317
R3795 VIN.n1024 VIN.n711 0.0212317
R3796 VIN.n1023 VIN.n713 0.0212317
R3797 VIN.n1020 VIN.n1019 0.0212317
R3798 VIN.n1016 VIN.n748 0.0212317
R3799 VIN.n1015 VIN.n750 0.0212317
R3800 VIN.n1012 VIN.n1011 0.0212317
R3801 VIN.n1008 VIN.n817 0.0212317
R3802 VIN.n1007 VIN.n819 0.0212317
R3803 VIN.n1004 VIN.n1003 0.0212317
R3804 VIN.n1000 VIN.n854 0.0212317
R3805 VIN.n999 VIN.n856 0.0212317
R3806 VIN.n995 VIN.n994 0.0212317
R3807 VIN.n991 VIN.n890 0.0212317
R3808 VIN.n990 VIN.n892 0.0212317
R3809 VIN.n987 VIN.n986 0.0212317
R3810 VIN.n1529 VIN.n73 0.01925
R3811 VIN.n59 VIN.n58 0.01925
R3812 VIN.n979 VIN.n973 0.0170882
R3813 VIN.n58 VIN 0.016125
R3814 VIN.n976 VIN.n964 0.0152059
R3815 VIN.n983 VIN.n964 0.0152059
R3816 VIN.n978 VIN.n969 0.0143235
R3817 VIN.n1336 VIN.n1295 0.013
R3818 VIN.n980 VIN.n969 0.0119789
R3819 VIN.n984 VIN 0.0116607
R3820 VIN.n982 VIN 0.0116607
R3821 VIN.n977 VIN.n974 0.0115588
R3822 VIN.n402 VIN 0.0101906
R3823 VIN.n1078 VIN.n384 0.00873917
R3824 VIN.n1105 VIN.n382 0.00873917
R3825 VIN.n1106 VIN.n1105 0.00873917
R3826 VIN.n1113 VIN.n364 0.00873917
R3827 VIN.n1124 VIN.n326 0.00873917
R3828 VIN.n1128 VIN.n326 0.00873917
R3829 VIN.n1131 VIN.n308 0.00873917
R3830 VIN.n1136 VIN.n308 0.00873917
R3831 VIN.n1143 VIN.n290 0.00873917
R3832 VIN.n1145 VIN.n272 0.00873917
R3833 VIN.n1150 VIN.n272 0.00873917
R3834 VIN.n1153 VIN.n254 0.00873917
R3835 VIN.n1158 VIN.n254 0.00873917
R3836 VIN.n1166 VIN.n236 0.00873917
R3837 VIN.n1169 VIN.n1168 0.00873917
R3838 VIN.n1175 VIN.n200 0.00873917
R3839 VIN.n1180 VIN.n200 0.00873917
R3840 VIN.n1188 VIN.n182 0.00873917
R3841 VIN.n1191 VIN.n1190 0.00873917
R3842 VIN.n1213 VIN.n1195 0.00873917
R3843 VIN.n1218 VIN.n162 0.00873917
R3844 VIN.n1243 VIN.n160 0.00873917
R3845 VIN.n1244 VIN.n1243 0.00873917
R3846 VIN.n1249 VIN.n1248 0.00873917
R3847 VIN.n1249 VIN.n139 0.00873917
R3848 VIN.n1256 VIN.n140 0.00873917
R3849 VIN.n1365 VIN.n136 0.00873917
R3850 VIN.n1366 VIN.n1365 0.00873917
R3851 VIN.n1372 VIN.n133 0.00873917
R3852 VIN.n1373 VIN.n1372 0.00873917
R3853 VIN.n1378 VIN.n128 0.00873917
R3854 VIN.n1385 VIN.n129 0.00873917
R3855 VIN.n129 VIN.n122 0.00873917
R3856 VIN.n1432 VIN.n120 0.00873917
R3857 VIN.n1433 VIN.n1432 0.00873917
R3858 VIN.n1457 VIN.n1439 0.00873917
R3859 VIN.n1462 VIN.n100 0.00873917
R3860 VIN.n1485 VIN.n98 0.00873917
R3861 VIN.n1486 VIN.n1485 0.00873917
R3862 VIN.n1491 VIN.n1490 0.00873917
R3863 VIN.n1491 VIN.n77 0.00873917
R3864 VIN.n1498 VIN.n78 0.00873917
R3865 VIN.n1569 VIN.n39 0.00873917
R3866 VIN.n1570 VIN.n1569 0.00873917
R3867 VIN.n1576 VIN.n36 0.00873917
R3868 VIN.n1577 VIN.n1576 0.00873917
R3869 VIN.n1584 VIN.n1583 0.00873917
R3870 VIN.n1113 VIN.n363 0.00815066
R3871 VIN.n1139 VIN.n1138 0.00815066
R3872 VIN.n1159 VIN.n1158 0.00815066
R3873 VIN.n1167 VIN.n1166 0.00815066
R3874 VIN.n1174 VIN.n1173 0.00815066
R3875 VIN.n1181 VIN.n1180 0.00815066
R3876 VIN.n1183 VIN.n182 0.00815066
R3877 VIN.n1189 VIN.n1188 0.00815066
R3878 VIN.n1212 VIN.n162 0.00815066
R3879 VIN.n1236 VIN.n160 0.00815066
R3880 VIN.n1257 VIN.n1256 0.00815066
R3881 VIN.n1359 VIN.n136 0.00815066
R3882 VIN.n1247 VIN.n158 0.00756215
R3883 VIN.n1082 VIN.n384 0.00697363
R3884 VIN.n1123 VIN.n1122 0.00697363
R3885 VIN.n1137 VIN.n1136 0.00697363
R3886 VIN.n1144 VIN.n1143 0.00697363
R3887 VIN.n1169 VIN.n218 0.00697363
R3888 VIN.n1360 VIN.n138 0.00697363
R3889 VIN.n1376 VIN.n131 0.00697363
R3890 VIN.n1377 VIN.n1376 0.00697363
R3891 VIN.n1386 VIN.n1385 0.00697363
R3892 VIN.n1426 VIN.n120 0.00697363
R3893 VIN.n1435 VIN.n1434 0.00697363
R3894 VIN.n1456 VIN.n100 0.00697363
R3895 VIN.n1564 VIN.n41 0.00697363
R3896 VIN.n1579 VIN.n18 0.00697363
R3897 VIN.n1342 VIN.n1341 0.00675
R3898 VIN.n978 VIN.n977 0.00602941
R3899 VIN.n1077 VIN.n1076 0.00579661
R3900 VIN.n1100 VIN.n1099 0.00579661
R3901 VIN.n1107 VIN.n1106 0.00579661
R3902 VIN.n364 VIN.n362 0.00579661
R3903 VIN.n1122 VIN.n1121 0.00579661
R3904 VIN.n1129 VIN.n1128 0.00579661
R3905 VIN.n1195 VIN.n164 0.00579661
R3906 VIN.n1219 VIN.n1218 0.00579661
R3907 VIN.n1439 VIN.n102 0.00579661
R3908 VIN.n1463 VIN.n1462 0.00579661
R3909 VIN.n1480 VIN.n98 0.00579661
R3910 VIN.n1499 VIN.n1498 0.00579661
R3911 VIN.n1563 VIN.n39 0.00579661
R3912 VIN.n1115 VIN.n344 0.0052081
R3913 VIN.n1152 VIN.n1151 0.0052081
R3914 VIN.n1489 VIN.n96 0.0052081
R3915 VIN.n1161 VIN.n1160 0.00461959
R3916 VIN.n1161 VIN.n236 0.00461959
R3917 VIN.n1368 VIN.n133 0.00461959
R3918 VIN.n1571 VIN.n1570 0.00461959
R3919 VIN.n1571 VIN.n36 0.00461959
R3920 VIN.n1578 VIN.n1577 0.00461959
R3921 VIN.n1579 VIN.n1578 0.00461959
R3922 VIN.n1584 VIN.n16 0.00461959
R3923 VIN.n1116 VIN.n1115 0.00403107
R3924 VIN.n1078 VIN.n1077 0.00344256
R3925 VIN.n1099 VIN.n382 0.00344256
R3926 VIN.n1108 VIN.n1107 0.00344256
R3927 VIN.n1116 VIN.n362 0.00344256
R3928 VIN.n1121 VIN.n344 0.00344256
R3929 VIN.n1191 VIN.n164 0.00344256
R3930 VIN.n1237 VIN.n1219 0.00344256
R3931 VIN.n1435 VIN.n102 0.00344256
R3932 VIN.n1481 VIN.n1463 0.00344256
R3933 VIN.n1481 VIN.n1480 0.00344256
R3934 VIN.n1486 VIN.n96 0.00344256
R3935 VIN.n1499 VIN.n77 0.00344256
R3936 VIN.n1564 VIN.n1563 0.00344256
R3937 VIN.n1368 VIN.n1367 0.00285405
R3938 VIN.n1100 VIN.n1082 0.00226554
R3939 VIN.n1124 VIN.n1123 0.00226554
R3940 VIN.n1131 VIN.n1130 0.00226554
R3941 VIN.n1138 VIN.n1137 0.00226554
R3942 VIN.n1145 VIN.n1144 0.00226554
R3943 VIN.n1151 VIN.n1150 0.00226554
R3944 VIN.n1153 VIN.n1152 0.00226554
R3945 VIN.n1173 VIN.n218 0.00226554
R3946 VIN.n140 VIN.n138 0.00226554
R3947 VIN.n1367 VIN.n1366 0.00226554
R3948 VIN.n1373 VIN.n131 0.00226554
R3949 VIN.n1378 VIN.n1377 0.00226554
R3950 VIN.n1386 VIN.n128 0.00226554
R3951 VIN.n1434 VIN.n1433 0.00226554
R3952 VIN.n1457 VIN.n1456 0.00226554
R3953 VIN.n78 VIN.n41 0.00226554
R3954 VIN.n1583 VIN.n18 0.00226554
R3955 VIN.n1130 VIN.n1129 0.00167702
R3956 VIN.n1427 VIN.n1426 0.00167702
R3957 VIN.n1043 VIN.n637 0.00110976
R3958 VIN.n1041 VIN.n1040 0.00110976
R3959 VIN.n1037 VIN.n639 0.00110976
R3960 VIN.n1036 VIN.n674 0.00110976
R3961 VIN.n1033 VIN.n1032 0.00110976
R3962 VIN.n1028 VIN.n676 0.00110976
R3963 VIN.n1027 VIN.n711 0.00110976
R3964 VIN.n1024 VIN.n1023 0.00110976
R3965 VIN.n1020 VIN.n713 0.00110976
R3966 VIN.n1019 VIN.n748 0.00110976
R3967 VIN.n1016 VIN.n1015 0.00110976
R3968 VIN.n1012 VIN.n750 0.00110976
R3969 VIN.n1011 VIN.n817 0.00110976
R3970 VIN.n1008 VIN.n1007 0.00110976
R3971 VIN.n1004 VIN.n819 0.00110976
R3972 VIN.n1003 VIN.n854 0.00110976
R3973 VIN.n1000 VIN.n999 0.00110976
R3974 VIN.n995 VIN.n856 0.00110976
R3975 VIN.n994 VIN.n890 0.00110976
R3976 VIN.n991 VIN.n990 0.00110976
R3977 VIN.n987 VIN.n892 0.00110976
R3978 VIN.n986 VIN.n985 0.00110976
R3979 VIN.n1108 VIN.n363 0.00108851
R3980 VIN.n1139 VIN.n290 0.00108851
R3981 VIN.n1160 VIN.n1159 0.00108851
R3982 VIN.n1168 VIN.n1167 0.00108851
R3983 VIN.n1175 VIN.n1174 0.00108851
R3984 VIN.n1182 VIN.n1181 0.00108851
R3985 VIN.n1183 VIN.n1182 0.00108851
R3986 VIN.n1190 VIN.n1189 0.00108851
R3987 VIN.n1213 VIN.n1212 0.00108851
R3988 VIN.n1237 VIN.n1236 0.00108851
R3989 VIN.n1244 VIN.n158 0.00108851
R3990 VIN.n1248 VIN.n1247 0.00108851
R3991 VIN.n1257 VIN.n139 0.00108851
R3992 VIN.n1360 VIN.n1359 0.00108851
R3993 VIN.n1427 VIN.n122 0.00108851
R3994 VIN.n1490 VIN.n1489 0.00108851
R3995 VIN VIN.n16 0.000853107
R3996 OUT.n1824 OUT.t709 655.111
R3997 OUT.n144 OUT.t357 655.111
R3998 OUT.n272 OUT.t876 655.111
R3999 OUT.n536 OUT.t1013 655.111
R4000 OUT.n794 OUT.t366 655.111
R4001 OUT.n923 OUT.t650 655.111
R4002 OUT.n1179 OUT.t995 655.111
R4003 OUT.n1437 OUT.t58 655.111
R4004 OUT.n1565 OUT.t639 655.111
R4005 OUT.n1952 OUT.t578 655.11
R4006 OUT.n17 OUT.t74 655.11
R4007 OUT.n400 OUT.t725 655.11
R4008 OUT.n662 OUT.t813 655.11
R4009 OUT.n1051 OUT.t453 655.11
R4010 OUT.n1309 OUT.t560 655.11
R4011 OUT.n1695 OUT.t198 655.11
R4012 OUT.n141 OUT.t535 654.879
R4013 OUT.n268 OUT.t800 654.879
R4014 OUT.n396 OUT.t306 654.879
R4015 OUT.n524 OUT.t170 654.879
R4016 OUT.n660 OUT.t446 654.879
R4017 OUT.n786 OUT.t251 654.879
R4018 OUT.n918 OUT.t820 654.879
R4019 OUT.n1047 OUT.t76 654.879
R4020 OUT.n1175 OUT.t903 654.879
R4021 OUT.n1303 OUT.t322 654.879
R4022 OUT.n1433 OUT.t901 654.879
R4023 OUT.n1561 OUT.t408 654.879
R4024 OUT.n1689 OUT.t977 654.879
R4025 OUT.n1819 OUT.t546 654.879
R4026 OUT.n1948 OUT.t40 654.879
R4027 OUT.n2076 OUT.t918 654.879
R4028 OUT.n119 OUT.t90 652.629
R4029 OUT.n99 OUT.t716 652.629
R4030 OUT.n764 OUT.t826 652.629
R4031 OUT.n744 OUT.t448 652.629
R4032 OUT.n1025 OUT.t666 652.629
R4033 OUT.n1005 OUT.t279 652.629
R4034 OUT.n1411 OUT.t1016 652.629
R4035 OUT.n1391 OUT.t11 652.629
R4036 OUT.n2054 OUT.t1 652.629
R4037 OUT.n2034 OUT.t27 652.629
R4038 OUT.n246 OUT.t368 652.628
R4039 OUT.n226 OUT.t1002 652.628
R4040 OUT.n502 OUT.t740 652.628
R4041 OUT.n482 OUT.t362 652.628
R4042 OUT.n896 OUT.t384 652.628
R4043 OUT.n876 OUT.t1021 652.628
R4044 OUT.n1153 OUT.t473 652.628
R4045 OUT.n1133 OUT.t78 652.628
R4046 OUT.n1539 OUT.t521 652.628
R4047 OUT.n1519 OUT.t541 652.628
R4048 OUT.n1797 OUT.t655 652.628
R4049 OUT.n1777 OUT.t671 652.628
R4050 OUT.n374 OUT.t889 652.628
R4051 OUT.n354 OUT.t510 652.628
R4052 OUT.n638 OUT.t1024 652.628
R4053 OUT.n618 OUT.t646 652.628
R4054 OUT.n1281 OUT.t438 652.628
R4055 OUT.n1261 OUT.t462 652.628
R4056 OUT.n1667 OUT.t64 652.628
R4057 OUT.n1647 OUT.t84 652.628
R4058 OUT.n1926 OUT.t152 652.628
R4059 OUT.n1906 OUT.t179 652.628
R4060 OUT.n107 OUT.t378 652.626
R4061 OUT.n752 OUT.t93 652.626
R4062 OUT.n1399 OUT.t82 652.626
R4063 OUT.n2042 OUT.t105 652.626
R4064 OUT.n1013 OUT.t941 652.626
R4065 OUT.n54 OUT.t54 652.625
R4066 OUT.n234 OUT.t661 652.625
R4067 OUT.n181 OUT.t330 652.625
R4068 OUT.n309 OUT.t847 652.625
R4069 OUT.n490 OUT.t8 652.625
R4070 OUT.n437 OUT.t704 652.625
R4071 OUT.n626 OUT.t285 652.625
R4072 OUT.n573 OUT.t988 652.625
R4073 OUT.n699 OUT.t788 652.625
R4074 OUT.n884 OUT.t667 652.625
R4075 OUT.n831 OUT.t342 652.625
R4076 OUT.n960 OUT.t629 652.625
R4077 OUT.n1141 OUT.t741 652.625
R4078 OUT.n1088 OUT.t434 652.625
R4079 OUT.n1269 OUT.t530 652.625
R4080 OUT.n1216 OUT.t36 652.625
R4081 OUT.n1346 OUT.t626 652.625
R4082 OUT.n1527 OUT.t617 652.625
R4083 OUT.n1474 OUT.t117 652.625
R4084 OUT.n1602 OUT.t690 652.625
R4085 OUT.n1785 OUT.t735 652.625
R4086 OUT.n1732 OUT.t256 652.625
R4087 OUT.n1914 OUT.t250 652.625
R4088 OUT.n1861 OUT.t771 652.625
R4089 OUT.n1989 OUT.t641 652.625
R4090 OUT.n362 OUT.t162 652.625
R4091 OUT.n1655 OUT.t168 652.625
R4092 OUT.n34 OUT.t492 652.625
R4093 OUT.n161 OUT.t757 652.625
R4094 OUT.n289 OUT.t266 652.625
R4095 OUT.n417 OUT.t120 652.625
R4096 OUT.n553 OUT.t401 652.625
R4097 OUT.n679 OUT.t210 652.625
R4098 OUT.n811 OUT.t772 652.625
R4099 OUT.n940 OUT.t33 652.625
R4100 OUT.n1068 OUT.t856 652.625
R4101 OUT.n1196 OUT.t254 652.625
R4102 OUT.n1326 OUT.t830 652.625
R4103 OUT.n1454 OUT.t335 652.625
R4104 OUT.n1582 OUT.t906 652.625
R4105 OUT.n1712 OUT.t476 652.625
R4106 OUT.n1841 OUT.t992 652.625
R4107 OUT.n1969 OUT.t845 652.625
R4108 OUT.n135 OUT.t449 652.624
R4109 OUT.n115 OUT.t518 652.624
R4110 OUT.n95 OUT.t796 652.624
R4111 OUT.n75 OUT.t420 652.624
R4112 OUT.n780 OUT.t169 652.624
R4113 OUT.n760 OUT.t236 652.624
R4114 OUT.n740 OUT.t526 652.624
R4115 OUT.n720 OUT.t136 652.624
R4116 OUT.n1041 OUT.t1020 652.624
R4117 OUT.n1021 OUT.t61 652.624
R4118 OUT.n1001 OUT.t348 652.624
R4119 OUT.n981 OUT.t984 652.624
R4120 OUT.n1427 OUT.t952 652.624
R4121 OUT.n1407 OUT.t1007 652.624
R4122 OUT.n1387 OUT.t268 652.624
R4123 OUT.n1367 OUT.t288 652.624
R4124 OUT.n2070 OUT.t962 652.624
R4125 OUT.n2050 OUT.t1023 652.624
R4126 OUT.n2030 OUT.t280 652.624
R4127 OUT.n2010 OUT.t304 652.624
R4128 OUT.n126 OUT.t17 652.622
R4129 OUT.n86 OUT.t274 652.622
R4130 OUT.n66 OUT.t902 652.622
R4131 OUT.n46 OUT.t174 652.622
R4132 OUT.n262 OUT.t713 652.622
R4133 OUT.n253 OUT.t300 652.622
R4134 OUT.n242 OUT.t785 652.622
R4135 OUT.n222 OUT.t57 652.622
R4136 OUT.n213 OUT.t552 652.622
R4137 OUT.n202 OUT.t689 652.622
R4138 OUT.n193 OUT.t167 652.622
R4139 OUT.n173 OUT.t452 652.622
R4140 OUT.n390 OUT.t229 652.622
R4141 OUT.n381 OUT.t818 652.622
R4142 OUT.n370 OUT.t290 652.622
R4143 OUT.n350 OUT.t583 652.622
R4144 OUT.n341 OUT.t46 652.622
R4145 OUT.n330 OUT.t201 652.622
R4146 OUT.n321 OUT.t685 652.622
R4147 OUT.n301 OUT.t968 652.622
R4148 OUT.n518 OUT.t79 652.622
R4149 OUT.n509 OUT.t676 652.622
R4150 OUT.n498 OUT.t148 652.622
R4151 OUT.n478 OUT.t442 652.622
R4152 OUT.n469 OUT.t927 652.622
R4153 OUT.n458 OUT.t50 652.622
R4154 OUT.n449 OUT.t545 652.622
R4155 OUT.n429 OUT.t823 652.622
R4156 OUT.n654 OUT.t359 652.622
R4157 OUT.n645 OUT.t954 652.622
R4158 OUT.n634 OUT.t429 652.622
R4159 OUT.n614 OUT.t708 652.622
R4160 OUT.n605 OUT.t194 652.622
R4161 OUT.n594 OUT.t327 652.622
R4162 OUT.n585 OUT.t814 652.622
R4163 OUT.n565 OUT.t81 652.622
R4164 OUT.n771 OUT.t755 652.622
R4165 OUT.n731 OUT.t1009 652.622
R4166 OUT.n711 OUT.t631 652.622
R4167 OUT.n691 OUT.t910 652.622
R4168 OUT.n912 OUT.t729 652.622
R4169 OUT.n903 OUT.t309 652.622
R4170 OUT.n892 OUT.t797 652.622
R4171 OUT.n872 OUT.t68 652.622
R4172 OUT.n863 OUT.t566 652.622
R4173 OUT.n852 OUT.t702 652.622
R4174 OUT.n843 OUT.t183 652.622
R4175 OUT.n823 OUT.t470 652.622
R4176 OUT.n1032 OUT.t596 652.622
R4177 OUT.n992 OUT.t835 652.622
R4178 OUT.n972 OUT.t458 652.622
R4179 OUT.n952 OUT.t734 652.622
R4180 OUT.n1169 OUT.t817 652.622
R4181 OUT.n1160 OUT.t396 652.622
R4182 OUT.n1149 OUT.t882 652.622
R4183 OUT.n1129 OUT.t160 652.622
R4184 OUT.n1120 OUT.t649 652.622
R4185 OUT.n1109 OUT.t783 652.622
R4186 OUT.n1100 OUT.t259 652.622
R4187 OUT.n1080 OUT.t555 652.622
R4188 OUT.n1297 OUT.t373 652.622
R4189 OUT.n1288 OUT.t549 652.622
R4190 OUT.n1277 OUT.t431 652.622
R4191 OUT.n1257 OUT.t701 652.622
R4192 OUT.n1248 OUT.t595 652.622
R4193 OUT.n1237 OUT.t721 652.622
R4194 OUT.n1228 OUT.t621 652.622
R4195 OUT.n1208 OUT.t891 652.622
R4196 OUT.n1418 OUT.t103 652.622
R4197 OUT.n1378 OUT.t153 652.622
R4198 OUT.n1358 OUT.t181 652.622
R4199 OUT.n1338 OUT.t460 652.622
R4200 OUT.n1555 OUT.t459 652.622
R4201 OUT.n1546 OUT.t633 652.622
R4202 OUT.n1535 OUT.t515 652.622
R4203 OUT.n1515 OUT.t786 652.622
R4204 OUT.n1506 OUT.t673 652.622
R4205 OUT.n1495 OUT.t808 652.622
R4206 OUT.n1486 OUT.t694 652.622
R4207 OUT.n1466 OUT.t974 652.622
R4208 OUT.n1683 OUT.t2 652.622
R4209 OUT.n1674 OUT.t187 652.622
R4210 OUT.n1663 OUT.t62 652.622
R4211 OUT.n1643 OUT.t339 652.622
R4212 OUT.n1634 OUT.t230 652.622
R4213 OUT.n1623 OUT.t364 652.622
R4214 OUT.n1614 OUT.t252 652.622
R4215 OUT.n1594 OUT.t532 652.622
R4216 OUT.n1813 OUT.t591 652.622
R4217 OUT.n1804 OUT.t753 652.622
R4218 OUT.n1793 OUT.t647 652.622
R4219 OUT.n1773 OUT.t925 652.622
R4220 OUT.n1764 OUT.t803 652.622
R4221 OUT.n1753 OUT.t944 652.622
R4222 OUT.n1744 OUT.t829 652.622
R4223 OUT.n1724 OUT.t87 652.622
R4224 OUT.n1942 OUT.t88 652.622
R4225 OUT.n1933 OUT.t264 652.622
R4226 OUT.n1922 OUT.t146 652.622
R4227 OUT.n1902 OUT.t430 652.622
R4228 OUT.n1893 OUT.t307 652.622
R4229 OUT.n1882 OUT.t450 652.622
R4230 OUT.n1873 OUT.t334 652.622
R4231 OUT.n1853 OUT.t620 652.622
R4232 OUT.n2061 OUT.t116 652.622
R4233 OUT.n2021 OUT.t171 652.622
R4234 OUT.n2001 OUT.t199 652.622
R4235 OUT.n1981 OUT.t475 652.622
R4236 OUT.n26 OUT.t610 652.622
R4237 OUT.n153 OUT.t881 652.622
R4238 OUT.n281 OUT.t386 652.622
R4239 OUT.n409 OUT.t249 652.622
R4240 OUT.n545 OUT.t528 652.622
R4241 OUT.n671 OUT.t326 652.622
R4242 OUT.n803 OUT.t896 652.622
R4243 OUT.n932 OUT.t163 652.622
R4244 OUT.n1060 OUT.t979 652.622
R4245 OUT.n1188 OUT.t89 652.622
R4246 OUT.n1318 OUT.t670 652.622
R4247 OUT.n1446 OUT.t175 652.622
R4248 OUT.n1574 OUT.t737 652.622
R4249 OUT.n1704 OUT.t305 652.622
R4250 OUT.n1833 OUT.t825 652.622
R4251 OUT.n1961 OUT.t687 652.622
R4252 OUT.n123 OUT.t41 652.621
R4253 OUT.n103 OUT.t680 652.621
R4254 OUT.n83 OUT.t293 652.621
R4255 OUT.n63 OUT.t585 652.621
R4256 OUT.n43 OUT.t202 652.621
R4257 OUT.n768 OUT.t780 652.621
R4258 OUT.n748 OUT.t399 652.621
R4259 OUT.n728 OUT.t7 652.621
R4260 OUT.n708 OUT.t301 652.621
R4261 OUT.n688 OUT.t937 652.621
R4262 OUT.n1029 OUT.t623 652.621
R4263 OUT.n1009 OUT.t233 652.621
R4264 OUT.n989 OUT.t857 652.621
R4265 OUT.n969 OUT.t133 652.621
R4266 OUT.n949 OUT.t758 652.621
R4267 OUT.n1415 OUT.t409 652.621
R4268 OUT.n1395 OUT.t437 652.621
R4269 OUT.n1375 OUT.t457 652.621
R4270 OUT.n1355 OUT.t726 652.621
R4271 OUT.n1335 OUT.t750 652.621
R4272 OUT.n2058 OUT.t426 652.621
R4273 OUT.n2038 OUT.t447 652.621
R4274 OUT.n2018 OUT.t474 652.621
R4275 OUT.n1998 OUT.t739 652.621
R4276 OUT.n1978 OUT.t767 652.621
R4277 OUT.n929 OUT.t189 652.62
R4278 OUT.n138 OUT.t488 652.62
R4279 OUT.n78 OUT.t137 652.62
R4280 OUT.n58 OUT.t761 652.62
R4281 OUT.n18 OUT.t815 652.62
R4282 OUT.n265 OUT.t752 652.62
R4283 OUT.n250 OUT.t321 652.62
R4284 OUT.n230 OUT.t957 652.62
R4285 OUT.n210 OUT.t577 652.62
R4286 OUT.n205 OUT.t414 652.62
R4287 OUT.n190 OUT.t854 652.62
R4288 OUT.n185 OUT.t23 652.62
R4289 OUT.n170 OUT.t478 652.62
R4290 OUT.n145 OUT.t73 652.62
R4291 OUT.n393 OUT.t263 652.62
R4292 OUT.n378 OUT.t839 652.62
R4293 OUT.n358 OUT.t465 652.62
R4294 OUT.n338 OUT.t70 652.62
R4295 OUT.n333 OUT.t934 652.62
R4296 OUT.n318 OUT.t361 652.62
R4297 OUT.n313 OUT.t557 652.62
R4298 OUT.n298 OUT.t998 652.62
R4299 OUT.n273 OUT.t603 652.62
R4300 OUT.n521 OUT.t119 652.62
R4301 OUT.n506 OUT.t695 652.62
R4302 OUT.n486 OUT.t313 652.62
R4303 OUT.n466 OUT.t947 652.62
R4304 OUT.n461 OUT.t790 652.62
R4305 OUT.n446 OUT.t224 652.62
R4306 OUT.n441 OUT.t405 652.62
R4307 OUT.n426 OUT.t850 652.62
R4308 OUT.n401 OUT.t455 652.62
R4309 OUT.n657 OUT.t398 652.62
R4310 OUT.n642 OUT.t976 652.62
R4311 OUT.n622 OUT.t597 652.62
R4312 OUT.n602 OUT.t215 652.62
R4313 OUT.n597 OUT.t45 652.62
R4314 OUT.n582 OUT.t504 652.62
R4315 OUT.n577 OUT.t681 652.62
R4316 OUT.n562 OUT.t108 652.62
R4317 OUT.n537 OUT.t722 652.62
R4318 OUT.n783 OUT.t206 652.62
R4319 OUT.n723 OUT.t872 652.62
R4320 OUT.n703 OUT.t495 652.62
R4321 OUT.n663 OUT.t540 652.62
R4322 OUT.n915 OUT.t770 652.62
R4323 OUT.n900 OUT.t336 652.62
R4324 OUT.n880 OUT.t967 652.62
R4325 OUT.n860 OUT.t587 652.62
R4326 OUT.n855 OUT.t432 652.62
R4327 OUT.n840 OUT.t873 652.62
R4328 OUT.n835 OUT.t37 652.62
R4329 OUT.n820 OUT.t493 652.62
R4330 OUT.n795 OUT.t83 652.62
R4331 OUT.n1044 OUT.t29 652.62
R4332 OUT.n984 OUT.t697 652.62
R4333 OUT.n964 OUT.t318 652.62
R4334 OUT.n924 OUT.t365 652.62
R4335 OUT.n1172 OUT.t853 652.62
R4336 OUT.n1157 OUT.t423 652.62
R4337 OUT.n1137 OUT.t31 652.62
R4338 OUT.n1117 OUT.t669 652.62
R4339 OUT.n1112 OUT.t517 652.62
R4340 OUT.n1097 OUT.t958 652.62
R4341 OUT.n1092 OUT.t122 652.62
R4342 OUT.n1077 OUT.t580 652.62
R4343 OUT.n1052 OUT.t177 652.62
R4344 OUT.n1300 OUT.t731 652.62
R4345 OUT.n1285 OUT.t842 652.62
R4346 OUT.n1265 OUT.t867 652.62
R4347 OUT.n1245 OUT.t892 652.62
R4348 OUT.n1240 OUT.t691 652.62
R4349 OUT.n1225 OUT.t157 652.62
R4350 OUT.n1220 OUT.t710 652.62
R4351 OUT.n1205 OUT.t185 652.62
R4352 OUT.n1180 OUT.t956 652.62
R4353 OUT.n1430 OUT.t299 652.62
R4354 OUT.n1370 OUT.t253 652.62
R4355 OUT.n1350 OUT.t278 652.62
R4356 OUT.n1310 OUT.t525 652.62
R4357 OUT.n1558 OUT.t816 652.62
R4358 OUT.n1543 OUT.t929 652.62
R4359 OUT.n1523 OUT.t949 652.62
R4360 OUT.n1503 OUT.t971 652.62
R4361 OUT.n1498 OUT.t769 652.62
R4362 OUT.n1483 OUT.t240 652.62
R4363 OUT.n1478 OUT.t794 652.62
R4364 OUT.n1463 OUT.t260 652.62
R4365 OUT.n1438 OUT.t16 652.62
R4366 OUT.n1686 OUT.t375 652.62
R4367 OUT.n1671 OUT.t484 652.62
R4368 OUT.n1651 OUT.t507 652.62
R4369 OUT.n1631 OUT.t531 652.62
R4370 OUT.n1626 OUT.t329 652.62
R4371 OUT.n1611 OUT.t802 652.62
R4372 OUT.n1606 OUT.t353 652.62
R4373 OUT.n1591 OUT.t828 652.62
R4374 OUT.n1566 OUT.t598 652.62
R4375 OUT.n1816 OUT.t955 652.62
R4376 OUT.n1801 OUT.t39 652.62
R4377 OUT.n1781 OUT.t65 652.62
R4378 OUT.n1761 OUT.t86 652.62
R4379 OUT.n1756 OUT.t907 652.62
R4380 OUT.n1741 OUT.t371 652.62
R4381 OUT.n1736 OUT.t936 652.62
R4382 OUT.n1721 OUT.t394 652.62
R4383 OUT.n1696 OUT.t155 652.62
R4384 OUT.n1945 OUT.t463 652.62
R4385 OUT.n1930 OUT.t569 652.62
R4386 OUT.n1910 OUT.t592 652.62
R4387 OUT.n1890 OUT.t619 652.62
R4388 OUT.n1885 OUT.t415 652.62
R4389 OUT.n1870 OUT.t886 652.62
R4390 OUT.n1865 OUT.t441 652.62
R4391 OUT.n1850 OUT.t914 652.62
R4392 OUT.n1825 OUT.t674 652.62
R4393 OUT.n2073 OUT.t311 652.62
R4394 OUT.n2013 OUT.t272 652.62
R4395 OUT.n1993 OUT.t291 652.62
R4396 OUT.n1953 OUT.t536 652.62
R4397 OUT.n38 OUT.t195 652.62
R4398 OUT.n23 OUT.t638 652.62
R4399 OUT.n165 OUT.t467 652.62
R4400 OUT.n150 OUT.t905 652.62
R4401 OUT.n293 OUT.t982 652.62
R4402 OUT.n278 OUT.t413 652.62
R4403 OUT.n421 OUT.t836 652.62
R4404 OUT.n406 OUT.t269 652.62
R4405 OUT.n557 OUT.t94 652.62
R4406 OUT.n542 OUT.t550 652.62
R4407 OUT.n683 OUT.t922 652.62
R4408 OUT.n668 OUT.t351 652.62
R4409 OUT.n815 OUT.t480 652.62
R4410 OUT.n800 OUT.t921 652.62
R4411 OUT.n944 OUT.t743 652.62
R4412 OUT.n1072 OUT.t562 652.62
R4413 OUT.n1057 OUT.t1003 652.62
R4414 OUT.n1200 OUT.t933 652.62
R4415 OUT.n1185 OUT.t395 652.62
R4416 OUT.n1330 OUT.t501 652.62
R4417 OUT.n1315 OUT.t969 652.62
R4418 OUT.n1458 OUT.t1019 652.62
R4419 OUT.n1443 OUT.t481 652.62
R4420 OUT.n1586 OUT.t575 652.62
R4421 OUT.n1571 OUT.t25 652.62
R4422 OUT.n1716 OUT.t129 652.62
R4423 OUT.n1701 OUT.t616 652.62
R4424 OUT.n1845 OUT.t659 652.62
R4425 OUT.n1830 OUT.t111 652.62
R4426 OUT.n1973 OUT.t514 652.62
R4427 OUT.n1958 OUT.t991 652.62
R4428 OUT.n131 OUT.t861 652.617
R4429 OUT.n130 OUT.t551 652.617
R4430 OUT.n111 OUT.t220 652.617
R4431 OUT.n110 OUT.t243 652.617
R4432 OUT.n91 OUT.t843 652.617
R4433 OUT.n90 OUT.t869 652.617
R4434 OUT.n71 OUT.t468 652.617
R4435 OUT.n70 OUT.t606 652.617
R4436 OUT.n51 OUT.t75 652.617
R4437 OUT.n50 OUT.t222 652.617
R4438 OUT.n258 OUT.t123 652.617
R4439 OUT.n257 OUT.t819 652.617
R4440 OUT.n238 OUT.t498 652.617
R4441 OUT.n237 OUT.t523 652.617
R4442 OUT.n218 OUT.t104 652.617
R4443 OUT.n217 OUT.t128 652.617
R4444 OUT.n198 OUT.t733 652.617
R4445 OUT.n197 OUT.t877 652.617
R4446 OUT.n178 OUT.t355 652.617
R4447 OUT.n177 OUT.t500 652.617
R4448 OUT.n386 OUT.t654 652.617
R4449 OUT.n385 OUT.t324 652.617
R4450 OUT.n366 OUT.t1017 652.617
R4451 OUT.n365 OUT.t13 652.617
R4452 OUT.n346 OUT.t634 652.617
R4453 OUT.n345 OUT.t658 652.617
R4454 OUT.n326 OUT.t248 652.617
R4455 OUT.n325 OUT.t381 652.617
R4456 OUT.n306 OUT.t875 652.617
R4457 OUT.n305 OUT.t1018 652.617
R4458 OUT.n514 OUT.t506 652.617
R4459 OUT.n513 OUT.t192 652.617
R4460 OUT.n494 OUT.t863 652.617
R4461 OUT.n493 OUT.t888 652.617
R4462 OUT.n474 OUT.t489 652.617
R4463 OUT.n473 OUT.t512 652.617
R4464 OUT.n454 OUT.t98 652.617
R4465 OUT.n453 OUT.t241 652.617
R4466 OUT.n434 OUT.t723 652.617
R4467 OUT.n433 OUT.t868 652.617
R4468 OUT.n650 OUT.t774 652.617
R4469 OUT.n649 OUT.t464 652.617
R4470 OUT.n630 OUT.t125 652.617
R4471 OUT.n629 OUT.t151 652.617
R4472 OUT.n610 OUT.t756 652.617
R4473 OUT.n609 OUT.t781 652.617
R4474 OUT.n590 OUT.t377 652.617
R4475 OUT.n589 OUT.t522 652.617
R4476 OUT.n570 OUT.t1010 652.617
R4477 OUT.n569 OUT.t127 652.617
R4478 OUT.n776 OUT.t589 652.617
R4479 OUT.n775 OUT.t265 652.617
R4480 OUT.n756 OUT.t950 652.617
R4481 OUT.n755 OUT.t973 652.617
R4482 OUT.n736 OUT.t570 652.617
R4483 OUT.n735 OUT.t594 652.617
R4484 OUT.n716 OUT.t191 652.617
R4485 OUT.n715 OUT.t319 652.617
R4486 OUT.n696 OUT.t809 652.617
R4487 OUT.n695 OUT.t953 652.617
R4488 OUT.n908 OUT.t142 652.617
R4489 OUT.n907 OUT.t833 652.617
R4490 OUT.n888 OUT.t509 652.617
R4491 OUT.n887 OUT.t534 652.617
R4492 OUT.n868 OUT.t118 652.617
R4493 OUT.n867 OUT.t144 652.617
R4494 OUT.n848 OUT.t744 652.617
R4495 OUT.n847 OUT.t887 652.617
R4496 OUT.n828 OUT.t367 652.617
R4497 OUT.n827 OUT.t508 652.617
R4498 OUT.n1037 OUT.t422 652.617
R4499 OUT.n1036 OUT.t91 652.617
R4500 OUT.n1017 OUT.t775 652.617
R4501 OUT.n1016 OUT.t799 652.617
R4502 OUT.n997 OUT.t397 652.617
R4503 OUT.n996 OUT.t424 652.617
R4504 OUT.n977 OUT.t6 652.617
R4505 OUT.n976 OUT.t150 652.617
R4506 OUT.n957 OUT.t651 652.617
R4507 OUT.n956 OUT.t779 652.617
R4508 OUT.n1165 OUT.t227 652.617
R4509 OUT.n1164 OUT.t920 652.617
R4510 OUT.n1145 OUT.t590 652.617
R4511 OUT.n1144 OUT.t618 652.617
R4512 OUT.n1125 OUT.t208 652.617
R4513 OUT.n1124 OUT.t231 652.617
R4514 OUT.n1105 OUT.t832 652.617
R4515 OUT.n1104 OUT.t972 652.617
R4516 OUT.n1085 OUT.t451 652.617
R4517 OUT.n1084 OUT.t593 652.617
R4518 OUT.n1293 OUT.t644 652.617
R4519 OUT.n1292 OUT.t176 652.617
R4520 OUT.n1273 OUT.t273 652.617
R4521 OUT.n1272 OUT.t579 652.617
R4522 OUT.n1253 OUT.t292 652.617
R4523 OUT.n1252 OUT.t601 652.617
R4524 OUT.n1233 OUT.t314 652.617
R4525 OUT.n1232 OUT.t277 652.617
R4526 OUT.n1213 OUT.t338 652.617
R4527 OUT.n1212 OUT.t298 652.617
R4528 OUT.n1423 OUT.t204 652.617
R4529 OUT.n1422 OUT.t745 652.617
R4530 OUT.n1403 OUT.t846 652.617
R4531 OUT.n1402 OUT.t135 652.617
R4532 OUT.n1383 OUT.t870 652.617
R4533 OUT.n1382 OUT.t159 652.617
R4534 OUT.n1363 OUT.t894 652.617
R4535 OUT.n1362 OUT.t851 652.617
R4536 OUT.n1343 OUT.t919 652.617
R4537 OUT.n1342 OUT.t878 652.617
R4538 OUT.n1551 OUT.t712 652.617
R4539 OUT.n1550 OUT.t257 652.617
R4540 OUT.n1531 OUT.t354 652.617
R4541 OUT.n1530 OUT.t662 652.617
R4542 OUT.n1511 OUT.t379 652.617
R4543 OUT.n1510 OUT.t677 652.617
R4544 OUT.n1491 OUT.t400 652.617
R4545 OUT.n1490 OUT.t358 652.617
R4546 OUT.n1471 OUT.t427 652.617
R4547 OUT.n1470 OUT.t382 652.617
R4548 OUT.n1679 OUT.t275 652.617
R4549 OUT.n1678 OUT.t824 652.617
R4550 OUT.n1659 OUT.t924 652.617
R4551 OUT.n1658 OUT.t212 652.617
R4552 OUT.n1639 OUT.t943 652.617
R4553 OUT.n1638 OUT.t234 652.617
R4554 OUT.n1619 OUT.t965 652.617
R4555 OUT.n1618 OUT.t931 652.617
R4556 OUT.n1599 OUT.t996 652.617
R4557 OUT.n1598 OUT.t951 652.617
R4558 OUT.n1809 OUT.t848 652.617
R4559 OUT.n1808 OUT.t390 652.617
R4560 OUT.n1789 OUT.t490 652.617
R4561 OUT.n1788 OUT.t782 652.617
R4562 OUT.n1769 OUT.t513 652.617
R4563 OUT.n1768 OUT.t806 652.617
R4564 OUT.n1749 OUT.t538 652.617
R4565 OUT.n1748 OUT.t496 652.617
R4566 OUT.n1729 OUT.t561 652.617
R4567 OUT.n1728 OUT.t520 652.617
R4568 OUT.n1938 OUT.t356 652.617
R4569 OUT.n1937 OUT.t911 652.617
R4570 OUT.n1918 OUT.t1005 652.617
R4571 OUT.n1917 OUT.t287 652.617
R4572 OUT.n1898 OUT.t3 652.617
R4573 OUT.n1897 OUT.t310 652.617
R4574 OUT.n1878 OUT.t32 652.617
R4575 OUT.n1877 OUT.t1015 652.617
R4576 OUT.n1858 OUT.t60 652.617
R4577 OUT.n1857 OUT.t10 652.617
R4578 OUT.n2066 OUT.t216 652.617
R4579 OUT.n2065 OUT.t765 652.617
R4580 OUT.n2046 OUT.t858 652.617
R4581 OUT.n2045 OUT.t147 652.617
R4582 OUT.n2026 OUT.t884 652.617
R4583 OUT.n2025 OUT.t173 652.617
R4584 OUT.n2006 OUT.t909 652.617
R4585 OUT.n2005 OUT.t866 652.617
R4586 OUT.n1986 OUT.t939 652.617
R4587 OUT.n1985 OUT.t890 652.617
R4588 OUT.n31 OUT.t635 652.617
R4589 OUT.n30 OUT.t302 652.617
R4590 OUT.n158 OUT.t900 652.617
R4591 OUT.n157 OUT.t584 652.617
R4592 OUT.n286 OUT.t406 652.617
R4593 OUT.n285 OUT.t80 652.617
R4594 OUT.n414 OUT.t261 652.617
R4595 OUT.n413 OUT.t959 652.617
R4596 OUT.n550 OUT.t542 652.617
R4597 OUT.n549 OUT.t223 652.617
R4598 OUT.n676 OUT.t343 652.617
R4599 OUT.n675 OUT.t19 652.617
R4600 OUT.n808 OUT.t917 652.617
R4601 OUT.n807 OUT.t602 652.617
R4602 OUT.n937 OUT.t182 652.617
R4603 OUT.n936 OUT.t871 652.617
R4604 OUT.n1065 OUT.t999 652.617
R4605 OUT.n1064 OUT.t678 652.617
R4606 OUT.n1193 OUT.t218 652.617
R4607 OUT.n1192 OUT.t763 652.617
R4608 OUT.n1323 OUT.t787 652.617
R4609 OUT.n1322 OUT.t332 652.617
R4610 OUT.n1451 OUT.t295 652.617
R4611 OUT.n1450 OUT.t849 652.617
R4612 OUT.n1579 OUT.t860 652.617
R4613 OUT.n1578 OUT.t407 652.617
R4614 OUT.n1709 OUT.t433 652.617
R4615 OUT.n1708 OUT.t985 652.617
R4616 OUT.n1838 OUT.t946 652.617
R4617 OUT.n1837 OUT.t497 652.617
R4618 OUT.n1966 OUT.t798 652.617
R4619 OUT.n1965 OUT.t345 652.617
R4620 OUT.n139 OUT.t511 652.615
R4621 OUT.n122 OUT.t66 652.615
R4622 OUT.n102 OUT.t698 652.615
R4623 OUT.n82 OUT.t315 652.615
R4624 OUT.n79 OUT.t109 652.615
R4625 OUT.n62 OUT.t611 652.615
R4626 OUT.n59 OUT.t736 652.615
R4627 OUT.n42 OUT.t139 652.615
R4628 OUT.n19 OUT.t793 652.615
R4629 OUT.n266 OUT.t776 652.615
R4630 OUT.n249 OUT.t346 652.615
R4631 OUT.n229 OUT.t978 652.615
R4632 OUT.n209 OUT.t600 652.615
R4633 OUT.n206 OUT.t387 652.615
R4634 OUT.n189 OUT.t880 652.615
R4635 OUT.n186 OUT.t1022 652.615
R4636 OUT.n169 OUT.t418 652.615
R4637 OUT.n146 OUT.t51 652.615
R4638 OUT.n394 OUT.t282 652.615
R4639 OUT.n377 OUT.t864 652.615
R4640 OUT.n357 OUT.t487 652.615
R4641 OUT.n337 OUT.t95 652.615
R4642 OUT.n334 OUT.t908 652.615
R4643 OUT.n317 OUT.t385 652.615
R4644 OUT.n314 OUT.t529 652.615
R4645 OUT.n297 OUT.t938 652.615
R4646 OUT.n274 OUT.t581 652.615
R4647 OUT.n522 OUT.t145 652.615
R4648 OUT.n505 OUT.t715 652.615
R4649 OUT.n485 OUT.t337 652.615
R4650 OUT.n465 OUT.t970 652.615
R4651 OUT.n462 OUT.t760 652.615
R4652 OUT.n445 OUT.t246 652.615
R4653 OUT.n442 OUT.t383 652.615
R4654 OUT.n425 OUT.t789 652.615
R4655 OUT.n402 OUT.t436 652.615
R4656 OUT.n658 OUT.t425 652.615
R4657 OUT.n641 OUT.t1001 652.615
R4658 OUT.n621 OUT.t624 652.615
R4659 OUT.n601 OUT.t237 652.615
R4660 OUT.n598 OUT.t20 652.615
R4661 OUT.n581 OUT.t527 652.615
R4662 OUT.n578 OUT.t664 652.615
R4663 OUT.n561 OUT.t44 652.615
R4664 OUT.n538 OUT.t703 652.615
R4665 OUT.n784 OUT.t228 652.615
R4666 OUT.n767 OUT.t805 652.615
R4667 OUT.n747 OUT.t428 652.615
R4668 OUT.n727 OUT.t34 652.615
R4669 OUT.n724 OUT.t844 652.615
R4670 OUT.n707 OUT.t323 652.615
R4671 OUT.n704 OUT.t471 652.615
R4672 OUT.n687 OUT.t874 652.615
R4673 OUT.n664 OUT.t519 652.615
R4674 OUT.n916 OUT.t795 652.615
R4675 OUT.n899 OUT.t360 652.615
R4676 OUT.n879 OUT.t997 652.615
R4677 OUT.n859 OUT.t615 652.615
R4678 OUT.n856 OUT.t402 652.615
R4679 OUT.n839 OUT.t897 652.615
R4680 OUT.n836 OUT.t12 652.615
R4681 OUT.n819 OUT.t435 652.615
R4682 OUT.n796 OUT.t63 652.615
R4683 OUT.n1045 OUT.t56 652.615
R4684 OUT.n1028 OUT.t645 652.615
R4685 OUT.n1008 OUT.t255 652.615
R4686 OUT.n988 OUT.t883 652.615
R4687 OUT.n985 OUT.t679 652.615
R4688 OUT.n968 OUT.t161 652.615
R4689 OUT.n965 OUT.t297 652.615
R4690 OUT.n948 OUT.t700 652.615
R4691 OUT.n925 OUT.t340 652.615
R4692 OUT.n1173 OUT.t879 652.615
R4693 OUT.n1156 OUT.t445 652.615
R4694 OUT.n1136 OUT.t59 652.615
R4695 OUT.n1116 OUT.t692 652.615
R4696 OUT.n1113 OUT.t491 652.615
R4697 OUT.n1096 OUT.t980 652.615
R4698 OUT.n1093 OUT.t99 652.615
R4699 OUT.n1076 OUT.t516 652.615
R4700 OUT.n1053 OUT.t149 652.615
R4701 OUT.n1301 OUT.t18 652.615
R4702 OUT.n1284 OUT.t131 652.615
R4703 OUT.n1264 OUT.t158 652.615
R4704 OUT.n1244 OUT.t186 652.615
R4705 OUT.n1241 OUT.t389 652.615
R4706 OUT.n1224 OUT.t461 652.615
R4707 OUT.n1221 OUT.t416 652.615
R4708 OUT.n1204 OUT.t325 652.615
R4709 OUT.n1181 OUT.t660 652.615
R4710 OUT.n1431 OUT.t607 652.615
R4711 OUT.n1414 OUT.t706 652.615
R4712 OUT.n1394 OUT.t724 652.615
R4713 OUT.n1374 OUT.t748 652.615
R4714 OUT.n1371 OUT.t963 652.615
R4715 OUT.n1354 OUT.t14 652.615
R4716 OUT.n1351 OUT.t993 652.615
R4717 OUT.n1334 OUT.t904 652.615
R4718 OUT.n1311 OUT.t221 652.615
R4719 OUT.n1559 OUT.t102 652.615
R4720 OUT.n1542 OUT.t217 652.615
R4721 OUT.n1522 OUT.t238 652.615
R4722 OUT.n1502 OUT.t258 652.615
R4723 OUT.n1499 OUT.t477 652.615
R4724 OUT.n1482 OUT.t544 652.615
R4725 OUT.n1479 OUT.t502 652.615
R4726 OUT.n1462 OUT.t412 652.615
R4727 OUT.n1439 OUT.t728 652.615
R4728 OUT.n1687 OUT.t675 652.615
R4729 OUT.n1670 OUT.t777 652.615
R4730 OUT.n1650 OUT.t801 652.615
R4731 OUT.n1630 OUT.t827 652.615
R4732 OUT.n1627 OUT.t21 652.615
R4733 OUT.n1610 OUT.t85 652.615
R4734 OUT.n1607 OUT.t48 652.615
R4735 OUT.n1590 OUT.t983 652.615
R4736 OUT.n1567 OUT.t286 652.615
R4737 OUT.n1817 OUT.t244 652.615
R4738 OUT.n1800 OUT.t344 652.615
R4739 OUT.n1780 OUT.t370 652.615
R4740 OUT.n1760 OUT.t393 652.615
R4741 OUT.n1757 OUT.t613 652.615
R4742 OUT.n1740 OUT.t672 652.615
R4743 OUT.n1737 OUT.t640 652.615
R4744 OUT.n1720 OUT.t548 652.615
R4745 OUT.n1697 OUT.t865 652.615
R4746 OUT.n1946 OUT.t754 652.615
R4747 OUT.n1929 OUT.t862 652.615
R4748 OUT.n1909 OUT.t885 652.615
R4749 OUT.n1889 OUT.t913 652.615
R4750 OUT.n1886 OUT.t107 652.615
R4751 OUT.n1869 OUT.t180 652.615
R4752 OUT.n1866 OUT.t134 652.615
R4753 OUT.n1849 OUT.t42 652.615
R4754 OUT.n1826 OUT.t372 652.615
R4755 OUT.n2074 OUT.t625 652.615
R4756 OUT.n2057 OUT.t714 652.615
R4757 OUT.n2037 OUT.t738 652.615
R4758 OUT.n2017 OUT.t766 652.615
R4759 OUT.n2014 OUT.t986 652.615
R4760 OUT.n1997 OUT.t28 652.615
R4761 OUT.n1994 OUT.t1011 652.615
R4762 OUT.n1977 OUT.t926 652.615
R4763 OUT.n1954 OUT.t232 652.615
R4764 OUT.n39 OUT.t165 652.615
R4765 OUT.n22 OUT.t764 652.615
R4766 OUT.n166 OUT.t443 652.615
R4767 OUT.n149 OUT.t22 652.615
R4768 OUT.n294 OUT.t960 652.615
R4769 OUT.n277 OUT.t556 652.615
R4770 OUT.n422 OUT.t810 652.615
R4771 OUT.n405 OUT.t410 652.615
R4772 OUT.n558 OUT.t69 652.615
R4773 OUT.n541 OUT.t683 652.615
R4774 OUT.n684 OUT.t898 652.615
R4775 OUT.n667 OUT.t494 652.615
R4776 OUT.n816 OUT.t454 652.615
R4777 OUT.n799 OUT.t38 652.615
R4778 OUT.n945 OUT.t718 652.615
R4779 OUT.n928 OUT.t317 652.615
R4780 OUT.n1073 OUT.t539 652.615
R4781 OUT.n1056 OUT.t124 652.615
R4782 OUT.n1201 OUT.t637 652.615
R4783 OUT.n1184 OUT.t350 652.615
R4784 OUT.n1331 OUT.t200 652.615
R4785 OUT.n1314 OUT.t932 652.615
R4786 OUT.n1459 OUT.t707 652.615
R4787 OUT.n1442 OUT.t439 652.615
R4788 OUT.n1587 OUT.t267 652.615
R4789 OUT.n1570 OUT.t1004 652.615
R4790 OUT.n1717 OUT.t841 652.615
R4791 OUT.n1700 OUT.t571 652.615
R4792 OUT.n1846 OUT.t347 652.615
R4793 OUT.n1829 OUT.t67 652.615
R4794 OUT.n1974 OUT.t214 652.615
R4795 OUT.n1957 OUT.t942 652.615
R4796 OUT.n134 OUT.t837 652.612
R4797 OUT.n127 OUT.t574 652.612
R4798 OUT.n114 OUT.t197 652.612
R4799 OUT.n94 OUT.t821 652.612
R4800 OUT.n87 OUT.t1014 652.612
R4801 OUT.n74 OUT.t444 652.612
R4802 OUT.n67 OUT.t632 652.612
R4803 OUT.n47 OUT.t242 652.612
R4804 OUT.n261 OUT.t100 652.612
R4805 OUT.n254 OUT.t840 652.612
R4806 OUT.n241 OUT.t472 652.612
R4807 OUT.n221 OUT.t77 652.612
R4808 OUT.n214 OUT.t270 652.612
R4809 OUT.n201 OUT.t711 652.612
R4810 OUT.n194 OUT.t899 652.612
R4811 OUT.n174 OUT.t524 652.612
R4812 OUT.n389 OUT.t630 652.612
R4813 OUT.n382 OUT.t349 652.612
R4814 OUT.n369 OUT.t990 652.612
R4815 OUT.n349 OUT.t608 652.612
R4816 OUT.n342 OUT.t784 652.612
R4817 OUT.n329 OUT.t225 652.612
R4818 OUT.n322 OUT.t403 652.612
R4819 OUT.n302 OUT.t15 652.612
R4820 OUT.n517 OUT.t483 652.612
R4821 OUT.n510 OUT.t211 652.612
R4822 OUT.n497 OUT.t838 652.612
R4823 OUT.n477 OUT.t466 652.612
R4824 OUT.n470 OUT.t652 652.612
R4825 OUT.n457 OUT.t72 652.612
R4826 OUT.n450 OUT.t262 652.612
R4827 OUT.n430 OUT.t893 652.612
R4828 OUT.n653 OUT.t749 652.612
R4829 OUT.n646 OUT.t486 652.612
R4830 OUT.n633 OUT.t101 652.612
R4831 OUT.n613 OUT.t730 652.612
R4832 OUT.n606 OUT.t923 652.612
R4833 OUT.n593 OUT.t352 652.612
R4834 OUT.n586 OUT.t543 652.612
R4835 OUT.n566 OUT.t154 652.612
R4836 OUT.n779 OUT.t567 652.612
R4837 OUT.n772 OUT.t284 652.612
R4838 OUT.n759 OUT.t930 652.612
R4839 OUT.n739 OUT.t547 652.612
R4840 OUT.n732 OUT.t720 652.612
R4841 OUT.n719 OUT.t164 652.612
R4842 OUT.n712 OUT.t341 652.612
R4843 OUT.n692 OUT.t975 652.612
R4844 OUT.n911 OUT.t113 652.612
R4845 OUT.n904 OUT.t855 652.612
R4846 OUT.n891 OUT.t485 652.612
R4847 OUT.n871 OUT.t92 652.612
R4848 OUT.n864 OUT.t281 652.612
R4849 OUT.n851 OUT.t719 652.612
R4850 OUT.n844 OUT.t915 652.612
R4851 OUT.n824 OUT.t533 652.612
R4852 OUT.n1040 OUT.t391 652.612
R4853 OUT.n1033 OUT.t115 652.612
R4854 OUT.n1020 OUT.t751 652.612
R4855 OUT.n1000 OUT.t374 652.612
R4856 OUT.n993 OUT.t564 652.612
R4857 OUT.n980 OUT.t1008 652.612
R4858 OUT.n973 OUT.t178 652.612
R4859 OUT.n953 OUT.t804 652.612
R4860 OUT.n1168 OUT.t205 652.612
R4861 OUT.n1161 OUT.t940 652.612
R4862 OUT.n1148 OUT.t568 652.612
R4863 OUT.n1128 OUT.t188 652.612
R4864 OUT.n1121 OUT.t363 652.612
R4865 OUT.n1108 OUT.t807 652.612
R4866 OUT.n1101 OUT.t1000 652.612
R4867 OUT.n1081 OUT.t622 652.612
R4868 OUT.n1296 OUT.t333 652.612
R4869 OUT.n1289 OUT.t482 652.612
R4870 OUT.n1276 OUT.t987 652.612
R4871 OUT.n1256 OUT.t1012 652.612
R4872 OUT.n1249 OUT.t559 652.612
R4873 OUT.n1236 OUT.t9 652.612
R4874 OUT.n1229 OUT.t582 652.612
R4875 OUT.n1209 OUT.t605 652.612
R4876 OUT.n1426 OUT.t912 652.612
R4877 OUT.n1419 OUT.t35 652.612
R4878 OUT.n1406 OUT.t554 652.612
R4879 OUT.n1386 OUT.t576 652.612
R4880 OUT.n1379 OUT.t112 652.612
R4881 OUT.n1366 OUT.t599 652.612
R4882 OUT.n1359 OUT.t140 652.612
R4883 OUT.n1339 OUT.t166 652.612
R4884 OUT.n1554 OUT.t421 652.612
R4885 OUT.n1547 OUT.t563 652.612
R4886 OUT.n1534 OUT.t49 652.612
R4887 OUT.n1514 OUT.t71 652.612
R4888 OUT.n1507 OUT.t643 652.612
R4889 OUT.n1494 OUT.t96 652.612
R4890 OUT.n1487 OUT.t665 652.612
R4891 OUT.n1467 OUT.t682 652.612
R4892 OUT.n1682 OUT.t989 652.612
R4893 OUT.n1675 OUT.t110 652.612
R4894 OUT.n1662 OUT.t628 652.612
R4895 OUT.n1642 OUT.t648 652.612
R4896 OUT.n1635 OUT.t196 652.612
R4897 OUT.n1622 OUT.t668 652.612
R4898 OUT.n1615 OUT.t219 652.612
R4899 OUT.n1595 OUT.t239 652.612
R4900 OUT.n1812 OUT.t558 652.612
R4901 OUT.n1805 OUT.t693 652.612
R4902 OUT.n1792 OUT.t193 652.612
R4903 OUT.n1772 OUT.t213 652.612
R4904 OUT.n1765 OUT.t762 652.612
R4905 OUT.n1752 OUT.t235 652.612
R4906 OUT.n1745 OUT.t791 652.612
R4907 OUT.n1725 OUT.t811 652.612
R4908 OUT.n1941 OUT.t52 652.612
R4909 OUT.n1934 OUT.t203 652.612
R4910 OUT.n1921 OUT.t699 652.612
R4911 OUT.n1901 OUT.t717 652.612
R4912 OUT.n1894 OUT.t276 652.612
R4913 OUT.n1881 OUT.t742 652.612
R4914 OUT.n1874 OUT.t294 652.612
R4915 OUT.n1854 OUT.t316 652.612
R4916 OUT.n2069 OUT.t928 652.612
R4917 OUT.n2062 OUT.t55 652.612
R4918 OUT.n2049 OUT.t565 652.612
R4919 OUT.n2029 OUT.t586 652.612
R4920 OUT.n2022 OUT.t130 652.612
R4921 OUT.n2009 OUT.t614 652.612
R4922 OUT.n2002 OUT.t156 652.612
R4923 OUT.n1982 OUT.t184 652.612
R4924 OUT.n27 OUT.t328 652.612
R4925 OUT.n154 OUT.t609 652.612
R4926 OUT.n282 OUT.t106 652.612
R4927 OUT.n410 OUT.t981 652.612
R4928 OUT.n546 OUT.t245 652.612
R4929 OUT.n672 OUT.t43 652.612
R4930 OUT.n804 OUT.t627 652.612
R4931 OUT.n933 OUT.t895 652.612
R4932 OUT.n1061 OUT.t696 652.612
R4933 OUT.n1189 OUT.t53 652.612
R4934 OUT.n1319 OUT.t642 652.612
R4935 OUT.n1447 OUT.t138 652.612
R4936 OUT.n1575 OUT.t705 652.612
R4937 OUT.n1705 OUT.t271 652.612
R4938 OUT.n1834 OUT.t792 652.612
R4939 OUT.n1962 OUT.t656 652.612
R4940 OUT.n106 OUT.t663 652.611
R4941 OUT.n55 OUT.t24 652.611
R4942 OUT.n233 OUT.t935 652.611
R4943 OUT.n182 OUT.t303 652.611
R4944 OUT.n361 OUT.t440 652.611
R4945 OUT.n310 OUT.t822 652.611
R4946 OUT.n489 OUT.t289 652.611
R4947 OUT.n438 OUT.t684 652.611
R4948 OUT.n625 OUT.t573 652.611
R4949 OUT.n574 OUT.t961 652.611
R4950 OUT.n751 OUT.t376 652.611
R4951 OUT.n700 OUT.t759 652.611
R4952 OUT.n883 OUT.t945 652.611
R4953 OUT.n832 OUT.t320 652.611
R4954 OUT.n1012 OUT.t209 652.611
R4955 OUT.n961 OUT.t604 652.611
R4956 OUT.n1140 OUT.t4 652.611
R4957 OUT.n1089 OUT.t404 652.611
R4958 OUT.n1268 OUT.t572 652.611
R4959 OUT.n1217 OUT.t746 652.611
R4960 OUT.n1398 OUT.t126 652.611
R4961 OUT.n1347 OUT.t312 652.611
R4962 OUT.n1526 OUT.t657 652.611
R4963 OUT.n1475 OUT.t831 652.611
R4964 OUT.n1654 OUT.t207 652.611
R4965 OUT.n1603 OUT.t388 652.611
R4966 OUT.n1784 OUT.t778 652.611
R4967 OUT.n1733 OUT.t966 652.611
R4968 OUT.n1913 OUT.t283 652.611
R4969 OUT.n1862 OUT.t479 652.611
R4970 OUT.n2041 OUT.t143 652.611
R4971 OUT.n1990 OUT.t331 652.611
R4972 OUT.n35 OUT.t469 652.611
R4973 OUT.n162 OUT.t732 652.611
R4974 OUT.n290 OUT.t247 652.611
R4975 OUT.n418 OUT.t97 652.611
R4976 OUT.n554 OUT.t380 652.611
R4977 OUT.n680 OUT.t190 652.611
R4978 OUT.n812 OUT.t747 652.611
R4979 OUT.n941 OUT.t5 652.611
R4980 OUT.n1069 OUT.t834 652.611
R4981 OUT.n1197 OUT.t964 652.611
R4982 OUT.n1327 OUT.t537 652.611
R4983 OUT.n1455 OUT.t30 652.611
R4984 OUT.n1583 OUT.t612 652.611
R4985 OUT.n1713 OUT.t172 652.611
R4986 OUT.n1842 OUT.t688 652.611
R4987 OUT.n1970 OUT.t553 652.611
R4988 OUT.n118 OUT.t114 652.607
R4989 OUT.n98 OUT.t859 652.607
R4990 OUT.n245 OUT.t392 652.607
R4991 OUT.n225 OUT.t121 652.607
R4992 OUT.n373 OUT.t916 652.607
R4993 OUT.n353 OUT.t653 652.607
R4994 OUT.n501 OUT.t768 652.607
R4995 OUT.n481 OUT.t505 652.607
R4996 OUT.n637 OUT.t26 652.607
R4997 OUT.n617 OUT.t773 652.607
R4998 OUT.n763 OUT.t852 652.607
R4999 OUT.n743 OUT.t588 652.607
R5000 OUT.n895 OUT.t411 652.607
R5001 OUT.n875 OUT.t141 652.607
R5002 OUT.n1024 OUT.t686 652.607
R5003 OUT.n1004 OUT.t419 652.607
R5004 OUT.n1152 OUT.t499 652.607
R5005 OUT.n1132 OUT.t226 652.607
R5006 OUT.n1280 OUT.t727 652.607
R5007 OUT.n1260 OUT.t417 652.607
R5008 OUT.n1410 OUT.t296 652.607
R5009 OUT.n1390 OUT.t994 652.607
R5010 OUT.n1538 OUT.t812 652.607
R5011 OUT.n1518 OUT.t503 652.607
R5012 OUT.n1666 OUT.t369 652.607
R5013 OUT.n1646 OUT.t47 652.607
R5014 OUT.n1796 OUT.t948 652.607
R5015 OUT.n1776 OUT.t636 652.607
R5016 OUT.n1925 OUT.t456 652.607
R5017 OUT.n1905 OUT.t132 652.607
R5018 OUT.n2053 OUT.t308 652.607
R5019 OUT.n2033 OUT.t1006 652.607
R5020 OUT.n2197 OUT.t0 22.4668
R5021 OUT.n2197 OUT.n2196 15.8408
R5022 OUT.n2182 OUT.n2181 4.78383
R5023 OUT.n1951 OUT.n1950 4.78383
R5024 OUT.n20 OUT.n19 4.5005
R5025 OUT.n18 OUT.n17 4.5005
R5026 OUT.n24 OUT.n23 4.5005
R5027 OUT.n22 OUT.n21 4.5005
R5028 OUT.n26 OUT.n25 4.5005
R5029 OUT.n28 OUT.n27 4.5005
R5030 OUT.n32 OUT.n31 4.5005
R5031 OUT.n30 OUT.n29 4.5005
R5032 OUT.n34 OUT.n33 4.5005
R5033 OUT.n36 OUT.n35 4.5005
R5034 OUT.n40 OUT.n39 4.5005
R5035 OUT.n38 OUT.n37 4.5005
R5036 OUT.n44 OUT.n43 4.5005
R5037 OUT.n42 OUT.n41 4.5005
R5038 OUT.n46 OUT.n45 4.5005
R5039 OUT.n48 OUT.n47 4.5005
R5040 OUT.n52 OUT.n51 4.5005
R5041 OUT.n50 OUT.n49 4.5005
R5042 OUT.n54 OUT.n53 4.5005
R5043 OUT.n56 OUT.n55 4.5005
R5044 OUT.n60 OUT.n59 4.5005
R5045 OUT.n58 OUT.n57 4.5005
R5046 OUT.n64 OUT.n63 4.5005
R5047 OUT.n62 OUT.n61 4.5005
R5048 OUT.n66 OUT.n65 4.5005
R5049 OUT.n68 OUT.n67 4.5005
R5050 OUT.n72 OUT.n71 4.5005
R5051 OUT.n70 OUT.n69 4.5005
R5052 OUT.n76 OUT.n75 4.5005
R5053 OUT.n74 OUT.n73 4.5005
R5054 OUT.n80 OUT.n79 4.5005
R5055 OUT.n78 OUT.n77 4.5005
R5056 OUT.n84 OUT.n83 4.5005
R5057 OUT.n82 OUT.n81 4.5005
R5058 OUT.n86 OUT.n85 4.5005
R5059 OUT.n88 OUT.n87 4.5005
R5060 OUT.n92 OUT.n91 4.5005
R5061 OUT.n90 OUT.n89 4.5005
R5062 OUT.n96 OUT.n95 4.5005
R5063 OUT.n94 OUT.n93 4.5005
R5064 OUT.n100 OUT.n99 4.5005
R5065 OUT.n98 OUT.n97 4.5005
R5066 OUT.n104 OUT.n103 4.5005
R5067 OUT.n102 OUT.n101 4.5005
R5068 OUT.n108 OUT.n107 4.5005
R5069 OUT.n106 OUT.n105 4.5005
R5070 OUT.n112 OUT.n111 4.5005
R5071 OUT.n110 OUT.n109 4.5005
R5072 OUT.n116 OUT.n115 4.5005
R5073 OUT.n114 OUT.n113 4.5005
R5074 OUT.n120 OUT.n119 4.5005
R5075 OUT.n118 OUT.n117 4.5005
R5076 OUT.n124 OUT.n123 4.5005
R5077 OUT.n122 OUT.n121 4.5005
R5078 OUT.n126 OUT.n125 4.5005
R5079 OUT.n128 OUT.n127 4.5005
R5080 OUT.n132 OUT.n131 4.5005
R5081 OUT.n130 OUT.n129 4.5005
R5082 OUT.n136 OUT.n135 4.5005
R5083 OUT.n134 OUT.n133 4.5005
R5084 OUT.n140 OUT.n139 4.5005
R5085 OUT.n138 OUT.n137 4.5005
R5086 OUT.n147 OUT.n146 4.5005
R5087 OUT.n145 OUT.n144 4.5005
R5088 OUT.n151 OUT.n150 4.5005
R5089 OUT.n149 OUT.n148 4.5005
R5090 OUT.n153 OUT.n152 4.5005
R5091 OUT.n155 OUT.n154 4.5005
R5092 OUT.n159 OUT.n158 4.5005
R5093 OUT.n157 OUT.n156 4.5005
R5094 OUT.n161 OUT.n160 4.5005
R5095 OUT.n163 OUT.n162 4.5005
R5096 OUT.n167 OUT.n166 4.5005
R5097 OUT.n165 OUT.n164 4.5005
R5098 OUT.n171 OUT.n170 4.5005
R5099 OUT.n169 OUT.n168 4.5005
R5100 OUT.n173 OUT.n172 4.5005
R5101 OUT.n175 OUT.n174 4.5005
R5102 OUT.n179 OUT.n178 4.5005
R5103 OUT.n177 OUT.n176 4.5005
R5104 OUT.n181 OUT.n180 4.5005
R5105 OUT.n183 OUT.n182 4.5005
R5106 OUT.n187 OUT.n186 4.5005
R5107 OUT.n185 OUT.n184 4.5005
R5108 OUT.n191 OUT.n190 4.5005
R5109 OUT.n189 OUT.n188 4.5005
R5110 OUT.n193 OUT.n192 4.5005
R5111 OUT.n195 OUT.n194 4.5005
R5112 OUT.n199 OUT.n198 4.5005
R5113 OUT.n197 OUT.n196 4.5005
R5114 OUT.n203 OUT.n202 4.5005
R5115 OUT.n201 OUT.n200 4.5005
R5116 OUT.n207 OUT.n206 4.5005
R5117 OUT.n205 OUT.n204 4.5005
R5118 OUT.n211 OUT.n210 4.5005
R5119 OUT.n209 OUT.n208 4.5005
R5120 OUT.n213 OUT.n212 4.5005
R5121 OUT.n215 OUT.n214 4.5005
R5122 OUT.n219 OUT.n218 4.5005
R5123 OUT.n217 OUT.n216 4.5005
R5124 OUT.n223 OUT.n222 4.5005
R5125 OUT.n221 OUT.n220 4.5005
R5126 OUT.n227 OUT.n226 4.5005
R5127 OUT.n225 OUT.n224 4.5005
R5128 OUT.n231 OUT.n230 4.5005
R5129 OUT.n229 OUT.n228 4.5005
R5130 OUT.n235 OUT.n234 4.5005
R5131 OUT.n233 OUT.n232 4.5005
R5132 OUT.n239 OUT.n238 4.5005
R5133 OUT.n237 OUT.n236 4.5005
R5134 OUT.n243 OUT.n242 4.5005
R5135 OUT.n241 OUT.n240 4.5005
R5136 OUT.n247 OUT.n246 4.5005
R5137 OUT.n245 OUT.n244 4.5005
R5138 OUT.n251 OUT.n250 4.5005
R5139 OUT.n249 OUT.n248 4.5005
R5140 OUT.n253 OUT.n252 4.5005
R5141 OUT.n255 OUT.n254 4.5005
R5142 OUT.n259 OUT.n258 4.5005
R5143 OUT.n257 OUT.n256 4.5005
R5144 OUT.n263 OUT.n262 4.5005
R5145 OUT.n261 OUT.n260 4.5005
R5146 OUT.n267 OUT.n266 4.5005
R5147 OUT.n265 OUT.n264 4.5005
R5148 OUT.n275 OUT.n274 4.5005
R5149 OUT.n273 OUT.n272 4.5005
R5150 OUT.n279 OUT.n278 4.5005
R5151 OUT.n277 OUT.n276 4.5005
R5152 OUT.n283 OUT.n282 4.5005
R5153 OUT.n281 OUT.n280 4.5005
R5154 OUT.n287 OUT.n286 4.5005
R5155 OUT.n285 OUT.n284 4.5005
R5156 OUT.n291 OUT.n290 4.5005
R5157 OUT.n289 OUT.n288 4.5005
R5158 OUT.n295 OUT.n294 4.5005
R5159 OUT.n293 OUT.n292 4.5005
R5160 OUT.n299 OUT.n298 4.5005
R5161 OUT.n297 OUT.n296 4.5005
R5162 OUT.n303 OUT.n302 4.5005
R5163 OUT.n301 OUT.n300 4.5005
R5164 OUT.n307 OUT.n306 4.5005
R5165 OUT.n305 OUT.n304 4.5005
R5166 OUT.n311 OUT.n310 4.5005
R5167 OUT.n309 OUT.n308 4.5005
R5168 OUT.n315 OUT.n314 4.5005
R5169 OUT.n313 OUT.n312 4.5005
R5170 OUT.n319 OUT.n318 4.5005
R5171 OUT.n317 OUT.n316 4.5005
R5172 OUT.n323 OUT.n322 4.5005
R5173 OUT.n321 OUT.n320 4.5005
R5174 OUT.n327 OUT.n326 4.5005
R5175 OUT.n325 OUT.n324 4.5005
R5176 OUT.n331 OUT.n330 4.5005
R5177 OUT.n329 OUT.n328 4.5005
R5178 OUT.n335 OUT.n334 4.5005
R5179 OUT.n333 OUT.n332 4.5005
R5180 OUT.n339 OUT.n338 4.5005
R5181 OUT.n337 OUT.n336 4.5005
R5182 OUT.n343 OUT.n342 4.5005
R5183 OUT.n341 OUT.n340 4.5005
R5184 OUT.n347 OUT.n346 4.5005
R5185 OUT.n345 OUT.n344 4.5005
R5186 OUT.n351 OUT.n350 4.5005
R5187 OUT.n349 OUT.n348 4.5005
R5188 OUT.n355 OUT.n354 4.5005
R5189 OUT.n353 OUT.n352 4.5005
R5190 OUT.n359 OUT.n358 4.5005
R5191 OUT.n357 OUT.n356 4.5005
R5192 OUT.n363 OUT.n362 4.5005
R5193 OUT.n361 OUT.n360 4.5005
R5194 OUT.n367 OUT.n366 4.5005
R5195 OUT.n365 OUT.n364 4.5005
R5196 OUT.n371 OUT.n370 4.5005
R5197 OUT.n369 OUT.n368 4.5005
R5198 OUT.n375 OUT.n374 4.5005
R5199 OUT.n373 OUT.n372 4.5005
R5200 OUT.n379 OUT.n378 4.5005
R5201 OUT.n377 OUT.n376 4.5005
R5202 OUT.n383 OUT.n382 4.5005
R5203 OUT.n381 OUT.n380 4.5005
R5204 OUT.n387 OUT.n386 4.5005
R5205 OUT.n385 OUT.n384 4.5005
R5206 OUT.n391 OUT.n390 4.5005
R5207 OUT.n389 OUT.n388 4.5005
R5208 OUT.n395 OUT.n394 4.5005
R5209 OUT.n393 OUT.n392 4.5005
R5210 OUT.n403 OUT.n402 4.5005
R5211 OUT.n401 OUT.n400 4.5005
R5212 OUT.n407 OUT.n406 4.5005
R5213 OUT.n405 OUT.n404 4.5005
R5214 OUT.n409 OUT.n408 4.5005
R5215 OUT.n411 OUT.n410 4.5005
R5216 OUT.n415 OUT.n414 4.5005
R5217 OUT.n413 OUT.n412 4.5005
R5218 OUT.n417 OUT.n416 4.5005
R5219 OUT.n419 OUT.n418 4.5005
R5220 OUT.n423 OUT.n422 4.5005
R5221 OUT.n421 OUT.n420 4.5005
R5222 OUT.n427 OUT.n426 4.5005
R5223 OUT.n425 OUT.n424 4.5005
R5224 OUT.n429 OUT.n428 4.5005
R5225 OUT.n431 OUT.n430 4.5005
R5226 OUT.n435 OUT.n434 4.5005
R5227 OUT.n433 OUT.n432 4.5005
R5228 OUT.n437 OUT.n436 4.5005
R5229 OUT.n439 OUT.n438 4.5005
R5230 OUT.n443 OUT.n442 4.5005
R5231 OUT.n441 OUT.n440 4.5005
R5232 OUT.n447 OUT.n446 4.5005
R5233 OUT.n445 OUT.n444 4.5005
R5234 OUT.n449 OUT.n448 4.5005
R5235 OUT.n451 OUT.n450 4.5005
R5236 OUT.n455 OUT.n454 4.5005
R5237 OUT.n453 OUT.n452 4.5005
R5238 OUT.n459 OUT.n458 4.5005
R5239 OUT.n457 OUT.n456 4.5005
R5240 OUT.n463 OUT.n462 4.5005
R5241 OUT.n461 OUT.n460 4.5005
R5242 OUT.n467 OUT.n466 4.5005
R5243 OUT.n465 OUT.n464 4.5005
R5244 OUT.n469 OUT.n468 4.5005
R5245 OUT.n471 OUT.n470 4.5005
R5246 OUT.n475 OUT.n474 4.5005
R5247 OUT.n473 OUT.n472 4.5005
R5248 OUT.n479 OUT.n478 4.5005
R5249 OUT.n477 OUT.n476 4.5005
R5250 OUT.n483 OUT.n482 4.5005
R5251 OUT.n481 OUT.n480 4.5005
R5252 OUT.n487 OUT.n486 4.5005
R5253 OUT.n485 OUT.n484 4.5005
R5254 OUT.n491 OUT.n490 4.5005
R5255 OUT.n489 OUT.n488 4.5005
R5256 OUT.n495 OUT.n494 4.5005
R5257 OUT.n493 OUT.n492 4.5005
R5258 OUT.n499 OUT.n498 4.5005
R5259 OUT.n497 OUT.n496 4.5005
R5260 OUT.n503 OUT.n502 4.5005
R5261 OUT.n501 OUT.n500 4.5005
R5262 OUT.n507 OUT.n506 4.5005
R5263 OUT.n505 OUT.n504 4.5005
R5264 OUT.n509 OUT.n508 4.5005
R5265 OUT.n511 OUT.n510 4.5005
R5266 OUT.n515 OUT.n514 4.5005
R5267 OUT.n513 OUT.n512 4.5005
R5268 OUT.n519 OUT.n518 4.5005
R5269 OUT.n517 OUT.n516 4.5005
R5270 OUT.n523 OUT.n522 4.5005
R5271 OUT.n521 OUT.n520 4.5005
R5272 OUT.n539 OUT.n538 4.5005
R5273 OUT.n537 OUT.n536 4.5005
R5274 OUT.n543 OUT.n542 4.5005
R5275 OUT.n541 OUT.n540 4.5005
R5276 OUT.n545 OUT.n544 4.5005
R5277 OUT.n547 OUT.n546 4.5005
R5278 OUT.n551 OUT.n550 4.5005
R5279 OUT.n549 OUT.n548 4.5005
R5280 OUT.n553 OUT.n552 4.5005
R5281 OUT.n555 OUT.n554 4.5005
R5282 OUT.n559 OUT.n558 4.5005
R5283 OUT.n557 OUT.n556 4.5005
R5284 OUT.n563 OUT.n562 4.5005
R5285 OUT.n561 OUT.n560 4.5005
R5286 OUT.n565 OUT.n564 4.5005
R5287 OUT.n567 OUT.n566 4.5005
R5288 OUT.n571 OUT.n570 4.5005
R5289 OUT.n569 OUT.n568 4.5005
R5290 OUT.n573 OUT.n572 4.5005
R5291 OUT.n575 OUT.n574 4.5005
R5292 OUT.n579 OUT.n578 4.5005
R5293 OUT.n577 OUT.n576 4.5005
R5294 OUT.n583 OUT.n582 4.5005
R5295 OUT.n581 OUT.n580 4.5005
R5296 OUT.n585 OUT.n584 4.5005
R5297 OUT.n587 OUT.n586 4.5005
R5298 OUT.n591 OUT.n590 4.5005
R5299 OUT.n589 OUT.n588 4.5005
R5300 OUT.n595 OUT.n594 4.5005
R5301 OUT.n593 OUT.n592 4.5005
R5302 OUT.n599 OUT.n598 4.5005
R5303 OUT.n597 OUT.n596 4.5005
R5304 OUT.n603 OUT.n602 4.5005
R5305 OUT.n601 OUT.n600 4.5005
R5306 OUT.n605 OUT.n604 4.5005
R5307 OUT.n607 OUT.n606 4.5005
R5308 OUT.n611 OUT.n610 4.5005
R5309 OUT.n609 OUT.n608 4.5005
R5310 OUT.n615 OUT.n614 4.5005
R5311 OUT.n613 OUT.n612 4.5005
R5312 OUT.n619 OUT.n618 4.5005
R5313 OUT.n617 OUT.n616 4.5005
R5314 OUT.n623 OUT.n622 4.5005
R5315 OUT.n621 OUT.n620 4.5005
R5316 OUT.n627 OUT.n626 4.5005
R5317 OUT.n625 OUT.n624 4.5005
R5318 OUT.n631 OUT.n630 4.5005
R5319 OUT.n629 OUT.n628 4.5005
R5320 OUT.n635 OUT.n634 4.5005
R5321 OUT.n633 OUT.n632 4.5005
R5322 OUT.n639 OUT.n638 4.5005
R5323 OUT.n637 OUT.n636 4.5005
R5324 OUT.n643 OUT.n642 4.5005
R5325 OUT.n641 OUT.n640 4.5005
R5326 OUT.n645 OUT.n644 4.5005
R5327 OUT.n647 OUT.n646 4.5005
R5328 OUT.n651 OUT.n650 4.5005
R5329 OUT.n649 OUT.n648 4.5005
R5330 OUT.n655 OUT.n654 4.5005
R5331 OUT.n653 OUT.n652 4.5005
R5332 OUT.n659 OUT.n658 4.5005
R5333 OUT.n657 OUT.n656 4.5005
R5334 OUT.n665 OUT.n664 4.5005
R5335 OUT.n663 OUT.n662 4.5005
R5336 OUT.n669 OUT.n668 4.5005
R5337 OUT.n667 OUT.n666 4.5005
R5338 OUT.n671 OUT.n670 4.5005
R5339 OUT.n673 OUT.n672 4.5005
R5340 OUT.n677 OUT.n676 4.5005
R5341 OUT.n675 OUT.n674 4.5005
R5342 OUT.n679 OUT.n678 4.5005
R5343 OUT.n681 OUT.n680 4.5005
R5344 OUT.n685 OUT.n684 4.5005
R5345 OUT.n683 OUT.n682 4.5005
R5346 OUT.n689 OUT.n688 4.5005
R5347 OUT.n687 OUT.n686 4.5005
R5348 OUT.n691 OUT.n690 4.5005
R5349 OUT.n693 OUT.n692 4.5005
R5350 OUT.n697 OUT.n696 4.5005
R5351 OUT.n695 OUT.n694 4.5005
R5352 OUT.n699 OUT.n698 4.5005
R5353 OUT.n701 OUT.n700 4.5005
R5354 OUT.n705 OUT.n704 4.5005
R5355 OUT.n703 OUT.n702 4.5005
R5356 OUT.n709 OUT.n708 4.5005
R5357 OUT.n707 OUT.n706 4.5005
R5358 OUT.n711 OUT.n710 4.5005
R5359 OUT.n713 OUT.n712 4.5005
R5360 OUT.n717 OUT.n716 4.5005
R5361 OUT.n715 OUT.n714 4.5005
R5362 OUT.n721 OUT.n720 4.5005
R5363 OUT.n719 OUT.n718 4.5005
R5364 OUT.n725 OUT.n724 4.5005
R5365 OUT.n723 OUT.n722 4.5005
R5366 OUT.n729 OUT.n728 4.5005
R5367 OUT.n727 OUT.n726 4.5005
R5368 OUT.n731 OUT.n730 4.5005
R5369 OUT.n733 OUT.n732 4.5005
R5370 OUT.n737 OUT.n736 4.5005
R5371 OUT.n735 OUT.n734 4.5005
R5372 OUT.n741 OUT.n740 4.5005
R5373 OUT.n739 OUT.n738 4.5005
R5374 OUT.n745 OUT.n744 4.5005
R5375 OUT.n743 OUT.n742 4.5005
R5376 OUT.n749 OUT.n748 4.5005
R5377 OUT.n747 OUT.n746 4.5005
R5378 OUT.n753 OUT.n752 4.5005
R5379 OUT.n751 OUT.n750 4.5005
R5380 OUT.n757 OUT.n756 4.5005
R5381 OUT.n755 OUT.n754 4.5005
R5382 OUT.n761 OUT.n760 4.5005
R5383 OUT.n759 OUT.n758 4.5005
R5384 OUT.n765 OUT.n764 4.5005
R5385 OUT.n763 OUT.n762 4.5005
R5386 OUT.n769 OUT.n768 4.5005
R5387 OUT.n767 OUT.n766 4.5005
R5388 OUT.n771 OUT.n770 4.5005
R5389 OUT.n773 OUT.n772 4.5005
R5390 OUT.n777 OUT.n776 4.5005
R5391 OUT.n775 OUT.n774 4.5005
R5392 OUT.n781 OUT.n780 4.5005
R5393 OUT.n779 OUT.n778 4.5005
R5394 OUT.n785 OUT.n784 4.5005
R5395 OUT.n783 OUT.n782 4.5005
R5396 OUT.n797 OUT.n796 4.5005
R5397 OUT.n795 OUT.n794 4.5005
R5398 OUT.n801 OUT.n800 4.5005
R5399 OUT.n799 OUT.n798 4.5005
R5400 OUT.n803 OUT.n802 4.5005
R5401 OUT.n805 OUT.n804 4.5005
R5402 OUT.n809 OUT.n808 4.5005
R5403 OUT.n807 OUT.n806 4.5005
R5404 OUT.n811 OUT.n810 4.5005
R5405 OUT.n813 OUT.n812 4.5005
R5406 OUT.n817 OUT.n816 4.5005
R5407 OUT.n815 OUT.n814 4.5005
R5408 OUT.n821 OUT.n820 4.5005
R5409 OUT.n819 OUT.n818 4.5005
R5410 OUT.n823 OUT.n822 4.5005
R5411 OUT.n825 OUT.n824 4.5005
R5412 OUT.n829 OUT.n828 4.5005
R5413 OUT.n827 OUT.n826 4.5005
R5414 OUT.n831 OUT.n830 4.5005
R5415 OUT.n833 OUT.n832 4.5005
R5416 OUT.n837 OUT.n836 4.5005
R5417 OUT.n835 OUT.n834 4.5005
R5418 OUT.n841 OUT.n840 4.5005
R5419 OUT.n839 OUT.n838 4.5005
R5420 OUT.n843 OUT.n842 4.5005
R5421 OUT.n845 OUT.n844 4.5005
R5422 OUT.n849 OUT.n848 4.5005
R5423 OUT.n847 OUT.n846 4.5005
R5424 OUT.n853 OUT.n852 4.5005
R5425 OUT.n851 OUT.n850 4.5005
R5426 OUT.n857 OUT.n856 4.5005
R5427 OUT.n855 OUT.n854 4.5005
R5428 OUT.n861 OUT.n860 4.5005
R5429 OUT.n859 OUT.n858 4.5005
R5430 OUT.n863 OUT.n862 4.5005
R5431 OUT.n865 OUT.n864 4.5005
R5432 OUT.n869 OUT.n868 4.5005
R5433 OUT.n867 OUT.n866 4.5005
R5434 OUT.n873 OUT.n872 4.5005
R5435 OUT.n871 OUT.n870 4.5005
R5436 OUT.n877 OUT.n876 4.5005
R5437 OUT.n875 OUT.n874 4.5005
R5438 OUT.n881 OUT.n880 4.5005
R5439 OUT.n879 OUT.n878 4.5005
R5440 OUT.n885 OUT.n884 4.5005
R5441 OUT.n883 OUT.n882 4.5005
R5442 OUT.n889 OUT.n888 4.5005
R5443 OUT.n887 OUT.n886 4.5005
R5444 OUT.n893 OUT.n892 4.5005
R5445 OUT.n891 OUT.n890 4.5005
R5446 OUT.n897 OUT.n896 4.5005
R5447 OUT.n895 OUT.n894 4.5005
R5448 OUT.n901 OUT.n900 4.5005
R5449 OUT.n899 OUT.n898 4.5005
R5450 OUT.n903 OUT.n902 4.5005
R5451 OUT.n905 OUT.n904 4.5005
R5452 OUT.n909 OUT.n908 4.5005
R5453 OUT.n907 OUT.n906 4.5005
R5454 OUT.n913 OUT.n912 4.5005
R5455 OUT.n911 OUT.n910 4.5005
R5456 OUT.n917 OUT.n916 4.5005
R5457 OUT.n915 OUT.n914 4.5005
R5458 OUT.n926 OUT.n925 4.5005
R5459 OUT.n924 OUT.n923 4.5005
R5460 OUT.n930 OUT.n929 4.5005
R5461 OUT.n928 OUT.n927 4.5005
R5462 OUT.n932 OUT.n931 4.5005
R5463 OUT.n934 OUT.n933 4.5005
R5464 OUT.n938 OUT.n937 4.5005
R5465 OUT.n936 OUT.n935 4.5005
R5466 OUT.n940 OUT.n939 4.5005
R5467 OUT.n942 OUT.n941 4.5005
R5468 OUT.n946 OUT.n945 4.5005
R5469 OUT.n944 OUT.n943 4.5005
R5470 OUT.n950 OUT.n949 4.5005
R5471 OUT.n948 OUT.n947 4.5005
R5472 OUT.n952 OUT.n951 4.5005
R5473 OUT.n954 OUT.n953 4.5005
R5474 OUT.n958 OUT.n957 4.5005
R5475 OUT.n956 OUT.n955 4.5005
R5476 OUT.n960 OUT.n959 4.5005
R5477 OUT.n962 OUT.n961 4.5005
R5478 OUT.n966 OUT.n965 4.5005
R5479 OUT.n964 OUT.n963 4.5005
R5480 OUT.n970 OUT.n969 4.5005
R5481 OUT.n968 OUT.n967 4.5005
R5482 OUT.n972 OUT.n971 4.5005
R5483 OUT.n974 OUT.n973 4.5005
R5484 OUT.n978 OUT.n977 4.5005
R5485 OUT.n976 OUT.n975 4.5005
R5486 OUT.n982 OUT.n981 4.5005
R5487 OUT.n980 OUT.n979 4.5005
R5488 OUT.n986 OUT.n985 4.5005
R5489 OUT.n984 OUT.n983 4.5005
R5490 OUT.n990 OUT.n989 4.5005
R5491 OUT.n988 OUT.n987 4.5005
R5492 OUT.n992 OUT.n991 4.5005
R5493 OUT.n994 OUT.n993 4.5005
R5494 OUT.n998 OUT.n997 4.5005
R5495 OUT.n996 OUT.n995 4.5005
R5496 OUT.n1002 OUT.n1001 4.5005
R5497 OUT.n1000 OUT.n999 4.5005
R5498 OUT.n1006 OUT.n1005 4.5005
R5499 OUT.n1004 OUT.n1003 4.5005
R5500 OUT.n1010 OUT.n1009 4.5005
R5501 OUT.n1008 OUT.n1007 4.5005
R5502 OUT.n1014 OUT.n1013 4.5005
R5503 OUT.n1012 OUT.n1011 4.5005
R5504 OUT.n1018 OUT.n1017 4.5005
R5505 OUT.n1016 OUT.n1015 4.5005
R5506 OUT.n1022 OUT.n1021 4.5005
R5507 OUT.n1020 OUT.n1019 4.5005
R5508 OUT.n1026 OUT.n1025 4.5005
R5509 OUT.n1024 OUT.n1023 4.5005
R5510 OUT.n1030 OUT.n1029 4.5005
R5511 OUT.n1028 OUT.n1027 4.5005
R5512 OUT.n1032 OUT.n1031 4.5005
R5513 OUT.n1034 OUT.n1033 4.5005
R5514 OUT.n1038 OUT.n1037 4.5005
R5515 OUT.n1036 OUT.n1035 4.5005
R5516 OUT.n1042 OUT.n1041 4.5005
R5517 OUT.n1040 OUT.n1039 4.5005
R5518 OUT.n1046 OUT.n1045 4.5005
R5519 OUT.n1044 OUT.n1043 4.5005
R5520 OUT.n1054 OUT.n1053 4.5005
R5521 OUT.n1052 OUT.n1051 4.5005
R5522 OUT.n1058 OUT.n1057 4.5005
R5523 OUT.n1056 OUT.n1055 4.5005
R5524 OUT.n1060 OUT.n1059 4.5005
R5525 OUT.n1062 OUT.n1061 4.5005
R5526 OUT.n1066 OUT.n1065 4.5005
R5527 OUT.n1064 OUT.n1063 4.5005
R5528 OUT.n1068 OUT.n1067 4.5005
R5529 OUT.n1070 OUT.n1069 4.5005
R5530 OUT.n1074 OUT.n1073 4.5005
R5531 OUT.n1072 OUT.n1071 4.5005
R5532 OUT.n1078 OUT.n1077 4.5005
R5533 OUT.n1076 OUT.n1075 4.5005
R5534 OUT.n1080 OUT.n1079 4.5005
R5535 OUT.n1082 OUT.n1081 4.5005
R5536 OUT.n1086 OUT.n1085 4.5005
R5537 OUT.n1084 OUT.n1083 4.5005
R5538 OUT.n1088 OUT.n1087 4.5005
R5539 OUT.n1090 OUT.n1089 4.5005
R5540 OUT.n1094 OUT.n1093 4.5005
R5541 OUT.n1092 OUT.n1091 4.5005
R5542 OUT.n1098 OUT.n1097 4.5005
R5543 OUT.n1096 OUT.n1095 4.5005
R5544 OUT.n1100 OUT.n1099 4.5005
R5545 OUT.n1102 OUT.n1101 4.5005
R5546 OUT.n1106 OUT.n1105 4.5005
R5547 OUT.n1104 OUT.n1103 4.5005
R5548 OUT.n1110 OUT.n1109 4.5005
R5549 OUT.n1108 OUT.n1107 4.5005
R5550 OUT.n1114 OUT.n1113 4.5005
R5551 OUT.n1112 OUT.n1111 4.5005
R5552 OUT.n1118 OUT.n1117 4.5005
R5553 OUT.n1116 OUT.n1115 4.5005
R5554 OUT.n1120 OUT.n1119 4.5005
R5555 OUT.n1122 OUT.n1121 4.5005
R5556 OUT.n1126 OUT.n1125 4.5005
R5557 OUT.n1124 OUT.n1123 4.5005
R5558 OUT.n1130 OUT.n1129 4.5005
R5559 OUT.n1128 OUT.n1127 4.5005
R5560 OUT.n1134 OUT.n1133 4.5005
R5561 OUT.n1132 OUT.n1131 4.5005
R5562 OUT.n1138 OUT.n1137 4.5005
R5563 OUT.n1136 OUT.n1135 4.5005
R5564 OUT.n1142 OUT.n1141 4.5005
R5565 OUT.n1140 OUT.n1139 4.5005
R5566 OUT.n1146 OUT.n1145 4.5005
R5567 OUT.n1144 OUT.n1143 4.5005
R5568 OUT.n1150 OUT.n1149 4.5005
R5569 OUT.n1148 OUT.n1147 4.5005
R5570 OUT.n1154 OUT.n1153 4.5005
R5571 OUT.n1152 OUT.n1151 4.5005
R5572 OUT.n1158 OUT.n1157 4.5005
R5573 OUT.n1156 OUT.n1155 4.5005
R5574 OUT.n1160 OUT.n1159 4.5005
R5575 OUT.n1162 OUT.n1161 4.5005
R5576 OUT.n1166 OUT.n1165 4.5005
R5577 OUT.n1164 OUT.n1163 4.5005
R5578 OUT.n1170 OUT.n1169 4.5005
R5579 OUT.n1168 OUT.n1167 4.5005
R5580 OUT.n1174 OUT.n1173 4.5005
R5581 OUT.n1172 OUT.n1171 4.5005
R5582 OUT.n1182 OUT.n1181 4.5005
R5583 OUT.n1180 OUT.n1179 4.5005
R5584 OUT.n1186 OUT.n1185 4.5005
R5585 OUT.n1184 OUT.n1183 4.5005
R5586 OUT.n1188 OUT.n1187 4.5005
R5587 OUT.n1190 OUT.n1189 4.5005
R5588 OUT.n1194 OUT.n1193 4.5005
R5589 OUT.n1192 OUT.n1191 4.5005
R5590 OUT.n1196 OUT.n1195 4.5005
R5591 OUT.n1198 OUT.n1197 4.5005
R5592 OUT.n1202 OUT.n1201 4.5005
R5593 OUT.n1200 OUT.n1199 4.5005
R5594 OUT.n1206 OUT.n1205 4.5005
R5595 OUT.n1204 OUT.n1203 4.5005
R5596 OUT.n1208 OUT.n1207 4.5005
R5597 OUT.n1210 OUT.n1209 4.5005
R5598 OUT.n1214 OUT.n1213 4.5005
R5599 OUT.n1212 OUT.n1211 4.5005
R5600 OUT.n1216 OUT.n1215 4.5005
R5601 OUT.n1218 OUT.n1217 4.5005
R5602 OUT.n1222 OUT.n1221 4.5005
R5603 OUT.n1220 OUT.n1219 4.5005
R5604 OUT.n1226 OUT.n1225 4.5005
R5605 OUT.n1224 OUT.n1223 4.5005
R5606 OUT.n1228 OUT.n1227 4.5005
R5607 OUT.n1230 OUT.n1229 4.5005
R5608 OUT.n1234 OUT.n1233 4.5005
R5609 OUT.n1232 OUT.n1231 4.5005
R5610 OUT.n1238 OUT.n1237 4.5005
R5611 OUT.n1236 OUT.n1235 4.5005
R5612 OUT.n1242 OUT.n1241 4.5005
R5613 OUT.n1240 OUT.n1239 4.5005
R5614 OUT.n1246 OUT.n1245 4.5005
R5615 OUT.n1244 OUT.n1243 4.5005
R5616 OUT.n1248 OUT.n1247 4.5005
R5617 OUT.n1250 OUT.n1249 4.5005
R5618 OUT.n1254 OUT.n1253 4.5005
R5619 OUT.n1252 OUT.n1251 4.5005
R5620 OUT.n1258 OUT.n1257 4.5005
R5621 OUT.n1256 OUT.n1255 4.5005
R5622 OUT.n1262 OUT.n1261 4.5005
R5623 OUT.n1260 OUT.n1259 4.5005
R5624 OUT.n1266 OUT.n1265 4.5005
R5625 OUT.n1264 OUT.n1263 4.5005
R5626 OUT.n1270 OUT.n1269 4.5005
R5627 OUT.n1268 OUT.n1267 4.5005
R5628 OUT.n1274 OUT.n1273 4.5005
R5629 OUT.n1272 OUT.n1271 4.5005
R5630 OUT.n1278 OUT.n1277 4.5005
R5631 OUT.n1276 OUT.n1275 4.5005
R5632 OUT.n1282 OUT.n1281 4.5005
R5633 OUT.n1280 OUT.n1279 4.5005
R5634 OUT.n1286 OUT.n1285 4.5005
R5635 OUT.n1284 OUT.n1283 4.5005
R5636 OUT.n1288 OUT.n1287 4.5005
R5637 OUT.n1290 OUT.n1289 4.5005
R5638 OUT.n1294 OUT.n1293 4.5005
R5639 OUT.n1292 OUT.n1291 4.5005
R5640 OUT.n1298 OUT.n1297 4.5005
R5641 OUT.n1296 OUT.n1295 4.5005
R5642 OUT.n1302 OUT.n1301 4.5005
R5643 OUT.n1300 OUT.n1299 4.5005
R5644 OUT.n1312 OUT.n1311 4.5005
R5645 OUT.n1310 OUT.n1309 4.5005
R5646 OUT.n1316 OUT.n1315 4.5005
R5647 OUT.n1314 OUT.n1313 4.5005
R5648 OUT.n1318 OUT.n1317 4.5005
R5649 OUT.n1320 OUT.n1319 4.5005
R5650 OUT.n1324 OUT.n1323 4.5005
R5651 OUT.n1322 OUT.n1321 4.5005
R5652 OUT.n1326 OUT.n1325 4.5005
R5653 OUT.n1328 OUT.n1327 4.5005
R5654 OUT.n1332 OUT.n1331 4.5005
R5655 OUT.n1330 OUT.n1329 4.5005
R5656 OUT.n1336 OUT.n1335 4.5005
R5657 OUT.n1334 OUT.n1333 4.5005
R5658 OUT.n1338 OUT.n1337 4.5005
R5659 OUT.n1340 OUT.n1339 4.5005
R5660 OUT.n1344 OUT.n1343 4.5005
R5661 OUT.n1342 OUT.n1341 4.5005
R5662 OUT.n1346 OUT.n1345 4.5005
R5663 OUT.n1348 OUT.n1347 4.5005
R5664 OUT.n1352 OUT.n1351 4.5005
R5665 OUT.n1350 OUT.n1349 4.5005
R5666 OUT.n1356 OUT.n1355 4.5005
R5667 OUT.n1354 OUT.n1353 4.5005
R5668 OUT.n1358 OUT.n1357 4.5005
R5669 OUT.n1360 OUT.n1359 4.5005
R5670 OUT.n1364 OUT.n1363 4.5005
R5671 OUT.n1362 OUT.n1361 4.5005
R5672 OUT.n1368 OUT.n1367 4.5005
R5673 OUT.n1366 OUT.n1365 4.5005
R5674 OUT.n1372 OUT.n1371 4.5005
R5675 OUT.n1370 OUT.n1369 4.5005
R5676 OUT.n1376 OUT.n1375 4.5005
R5677 OUT.n1374 OUT.n1373 4.5005
R5678 OUT.n1378 OUT.n1377 4.5005
R5679 OUT.n1380 OUT.n1379 4.5005
R5680 OUT.n1384 OUT.n1383 4.5005
R5681 OUT.n1382 OUT.n1381 4.5005
R5682 OUT.n1388 OUT.n1387 4.5005
R5683 OUT.n1386 OUT.n1385 4.5005
R5684 OUT.n1392 OUT.n1391 4.5005
R5685 OUT.n1390 OUT.n1389 4.5005
R5686 OUT.n1396 OUT.n1395 4.5005
R5687 OUT.n1394 OUT.n1393 4.5005
R5688 OUT.n1400 OUT.n1399 4.5005
R5689 OUT.n1398 OUT.n1397 4.5005
R5690 OUT.n1404 OUT.n1403 4.5005
R5691 OUT.n1402 OUT.n1401 4.5005
R5692 OUT.n1408 OUT.n1407 4.5005
R5693 OUT.n1406 OUT.n1405 4.5005
R5694 OUT.n1412 OUT.n1411 4.5005
R5695 OUT.n1410 OUT.n1409 4.5005
R5696 OUT.n1416 OUT.n1415 4.5005
R5697 OUT.n1414 OUT.n1413 4.5005
R5698 OUT.n1418 OUT.n1417 4.5005
R5699 OUT.n1420 OUT.n1419 4.5005
R5700 OUT.n1424 OUT.n1423 4.5005
R5701 OUT.n1422 OUT.n1421 4.5005
R5702 OUT.n1428 OUT.n1427 4.5005
R5703 OUT.n1426 OUT.n1425 4.5005
R5704 OUT.n1432 OUT.n1431 4.5005
R5705 OUT.n1430 OUT.n1429 4.5005
R5706 OUT.n1440 OUT.n1439 4.5005
R5707 OUT.n1438 OUT.n1437 4.5005
R5708 OUT.n1444 OUT.n1443 4.5005
R5709 OUT.n1442 OUT.n1441 4.5005
R5710 OUT.n1446 OUT.n1445 4.5005
R5711 OUT.n1448 OUT.n1447 4.5005
R5712 OUT.n1452 OUT.n1451 4.5005
R5713 OUT.n1450 OUT.n1449 4.5005
R5714 OUT.n1454 OUT.n1453 4.5005
R5715 OUT.n1456 OUT.n1455 4.5005
R5716 OUT.n1460 OUT.n1459 4.5005
R5717 OUT.n1458 OUT.n1457 4.5005
R5718 OUT.n1464 OUT.n1463 4.5005
R5719 OUT.n1462 OUT.n1461 4.5005
R5720 OUT.n1466 OUT.n1465 4.5005
R5721 OUT.n1468 OUT.n1467 4.5005
R5722 OUT.n1472 OUT.n1471 4.5005
R5723 OUT.n1470 OUT.n1469 4.5005
R5724 OUT.n1474 OUT.n1473 4.5005
R5725 OUT.n1476 OUT.n1475 4.5005
R5726 OUT.n1480 OUT.n1479 4.5005
R5727 OUT.n1478 OUT.n1477 4.5005
R5728 OUT.n1484 OUT.n1483 4.5005
R5729 OUT.n1482 OUT.n1481 4.5005
R5730 OUT.n1486 OUT.n1485 4.5005
R5731 OUT.n1488 OUT.n1487 4.5005
R5732 OUT.n1492 OUT.n1491 4.5005
R5733 OUT.n1490 OUT.n1489 4.5005
R5734 OUT.n1496 OUT.n1495 4.5005
R5735 OUT.n1494 OUT.n1493 4.5005
R5736 OUT.n1500 OUT.n1499 4.5005
R5737 OUT.n1498 OUT.n1497 4.5005
R5738 OUT.n1504 OUT.n1503 4.5005
R5739 OUT.n1502 OUT.n1501 4.5005
R5740 OUT.n1506 OUT.n1505 4.5005
R5741 OUT.n1508 OUT.n1507 4.5005
R5742 OUT.n1512 OUT.n1511 4.5005
R5743 OUT.n1510 OUT.n1509 4.5005
R5744 OUT.n1516 OUT.n1515 4.5005
R5745 OUT.n1514 OUT.n1513 4.5005
R5746 OUT.n1520 OUT.n1519 4.5005
R5747 OUT.n1518 OUT.n1517 4.5005
R5748 OUT.n1524 OUT.n1523 4.5005
R5749 OUT.n1522 OUT.n1521 4.5005
R5750 OUT.n1528 OUT.n1527 4.5005
R5751 OUT.n1526 OUT.n1525 4.5005
R5752 OUT.n1532 OUT.n1531 4.5005
R5753 OUT.n1530 OUT.n1529 4.5005
R5754 OUT.n1536 OUT.n1535 4.5005
R5755 OUT.n1534 OUT.n1533 4.5005
R5756 OUT.n1540 OUT.n1539 4.5005
R5757 OUT.n1538 OUT.n1537 4.5005
R5758 OUT.n1544 OUT.n1543 4.5005
R5759 OUT.n1542 OUT.n1541 4.5005
R5760 OUT.n1546 OUT.n1545 4.5005
R5761 OUT.n1548 OUT.n1547 4.5005
R5762 OUT.n1552 OUT.n1551 4.5005
R5763 OUT.n1550 OUT.n1549 4.5005
R5764 OUT.n1556 OUT.n1555 4.5005
R5765 OUT.n1554 OUT.n1553 4.5005
R5766 OUT.n1560 OUT.n1559 4.5005
R5767 OUT.n1558 OUT.n1557 4.5005
R5768 OUT.n1568 OUT.n1567 4.5005
R5769 OUT.n1566 OUT.n1565 4.5005
R5770 OUT.n1572 OUT.n1571 4.5005
R5771 OUT.n1570 OUT.n1569 4.5005
R5772 OUT.n1576 OUT.n1575 4.5005
R5773 OUT.n1574 OUT.n1573 4.5005
R5774 OUT.n1580 OUT.n1579 4.5005
R5775 OUT.n1578 OUT.n1577 4.5005
R5776 OUT.n1584 OUT.n1583 4.5005
R5777 OUT.n1582 OUT.n1581 4.5005
R5778 OUT.n1588 OUT.n1587 4.5005
R5779 OUT.n1586 OUT.n1585 4.5005
R5780 OUT.n1592 OUT.n1591 4.5005
R5781 OUT.n1590 OUT.n1589 4.5005
R5782 OUT.n1596 OUT.n1595 4.5005
R5783 OUT.n1594 OUT.n1593 4.5005
R5784 OUT.n1600 OUT.n1599 4.5005
R5785 OUT.n1598 OUT.n1597 4.5005
R5786 OUT.n1604 OUT.n1603 4.5005
R5787 OUT.n1602 OUT.n1601 4.5005
R5788 OUT.n1608 OUT.n1607 4.5005
R5789 OUT.n1606 OUT.n1605 4.5005
R5790 OUT.n1612 OUT.n1611 4.5005
R5791 OUT.n1610 OUT.n1609 4.5005
R5792 OUT.n1616 OUT.n1615 4.5005
R5793 OUT.n1614 OUT.n1613 4.5005
R5794 OUT.n1620 OUT.n1619 4.5005
R5795 OUT.n1618 OUT.n1617 4.5005
R5796 OUT.n1624 OUT.n1623 4.5005
R5797 OUT.n1622 OUT.n1621 4.5005
R5798 OUT.n1628 OUT.n1627 4.5005
R5799 OUT.n1626 OUT.n1625 4.5005
R5800 OUT.n1632 OUT.n1631 4.5005
R5801 OUT.n1630 OUT.n1629 4.5005
R5802 OUT.n1636 OUT.n1635 4.5005
R5803 OUT.n1634 OUT.n1633 4.5005
R5804 OUT.n1640 OUT.n1639 4.5005
R5805 OUT.n1638 OUT.n1637 4.5005
R5806 OUT.n1644 OUT.n1643 4.5005
R5807 OUT.n1642 OUT.n1641 4.5005
R5808 OUT.n1648 OUT.n1647 4.5005
R5809 OUT.n1646 OUT.n1645 4.5005
R5810 OUT.n1652 OUT.n1651 4.5005
R5811 OUT.n1650 OUT.n1649 4.5005
R5812 OUT.n1656 OUT.n1655 4.5005
R5813 OUT.n1654 OUT.n1653 4.5005
R5814 OUT.n1660 OUT.n1659 4.5005
R5815 OUT.n1658 OUT.n1657 4.5005
R5816 OUT.n1664 OUT.n1663 4.5005
R5817 OUT.n1662 OUT.n1661 4.5005
R5818 OUT.n1668 OUT.n1667 4.5005
R5819 OUT.n1666 OUT.n1665 4.5005
R5820 OUT.n1672 OUT.n1671 4.5005
R5821 OUT.n1670 OUT.n1669 4.5005
R5822 OUT.n1676 OUT.n1675 4.5005
R5823 OUT.n1674 OUT.n1673 4.5005
R5824 OUT.n1680 OUT.n1679 4.5005
R5825 OUT.n1678 OUT.n1677 4.5005
R5826 OUT.n1684 OUT.n1683 4.5005
R5827 OUT.n1682 OUT.n1681 4.5005
R5828 OUT.n1688 OUT.n1687 4.5005
R5829 OUT.n1686 OUT.n1685 4.5005
R5830 OUT.n1698 OUT.n1697 4.5005
R5831 OUT.n1696 OUT.n1695 4.5005
R5832 OUT.n1702 OUT.n1701 4.5005
R5833 OUT.n1700 OUT.n1699 4.5005
R5834 OUT.n1704 OUT.n1703 4.5005
R5835 OUT.n1706 OUT.n1705 4.5005
R5836 OUT.n1710 OUT.n1709 4.5005
R5837 OUT.n1708 OUT.n1707 4.5005
R5838 OUT.n1712 OUT.n1711 4.5005
R5839 OUT.n1714 OUT.n1713 4.5005
R5840 OUT.n1718 OUT.n1717 4.5005
R5841 OUT.n1716 OUT.n1715 4.5005
R5842 OUT.n1722 OUT.n1721 4.5005
R5843 OUT.n1720 OUT.n1719 4.5005
R5844 OUT.n1724 OUT.n1723 4.5005
R5845 OUT.n1726 OUT.n1725 4.5005
R5846 OUT.n1730 OUT.n1729 4.5005
R5847 OUT.n1728 OUT.n1727 4.5005
R5848 OUT.n1732 OUT.n1731 4.5005
R5849 OUT.n1734 OUT.n1733 4.5005
R5850 OUT.n1738 OUT.n1737 4.5005
R5851 OUT.n1736 OUT.n1735 4.5005
R5852 OUT.n1742 OUT.n1741 4.5005
R5853 OUT.n1740 OUT.n1739 4.5005
R5854 OUT.n1744 OUT.n1743 4.5005
R5855 OUT.n1746 OUT.n1745 4.5005
R5856 OUT.n1750 OUT.n1749 4.5005
R5857 OUT.n1748 OUT.n1747 4.5005
R5858 OUT.n1754 OUT.n1753 4.5005
R5859 OUT.n1752 OUT.n1751 4.5005
R5860 OUT.n1758 OUT.n1757 4.5005
R5861 OUT.n1756 OUT.n1755 4.5005
R5862 OUT.n1762 OUT.n1761 4.5005
R5863 OUT.n1760 OUT.n1759 4.5005
R5864 OUT.n1764 OUT.n1763 4.5005
R5865 OUT.n1766 OUT.n1765 4.5005
R5866 OUT.n1770 OUT.n1769 4.5005
R5867 OUT.n1768 OUT.n1767 4.5005
R5868 OUT.n1774 OUT.n1773 4.5005
R5869 OUT.n1772 OUT.n1771 4.5005
R5870 OUT.n1778 OUT.n1777 4.5005
R5871 OUT.n1776 OUT.n1775 4.5005
R5872 OUT.n1782 OUT.n1781 4.5005
R5873 OUT.n1780 OUT.n1779 4.5005
R5874 OUT.n1786 OUT.n1785 4.5005
R5875 OUT.n1784 OUT.n1783 4.5005
R5876 OUT.n1790 OUT.n1789 4.5005
R5877 OUT.n1788 OUT.n1787 4.5005
R5878 OUT.n1794 OUT.n1793 4.5005
R5879 OUT.n1792 OUT.n1791 4.5005
R5880 OUT.n1798 OUT.n1797 4.5005
R5881 OUT.n1796 OUT.n1795 4.5005
R5882 OUT.n1802 OUT.n1801 4.5005
R5883 OUT.n1800 OUT.n1799 4.5005
R5884 OUT.n1804 OUT.n1803 4.5005
R5885 OUT.n1806 OUT.n1805 4.5005
R5886 OUT.n1810 OUT.n1809 4.5005
R5887 OUT.n1808 OUT.n1807 4.5005
R5888 OUT.n1814 OUT.n1813 4.5005
R5889 OUT.n1812 OUT.n1811 4.5005
R5890 OUT.n1818 OUT.n1817 4.5005
R5891 OUT.n1816 OUT.n1815 4.5005
R5892 OUT.n1827 OUT.n1826 4.5005
R5893 OUT.n1825 OUT.n1824 4.5005
R5894 OUT.n1831 OUT.n1830 4.5005
R5895 OUT.n1829 OUT.n1828 4.5005
R5896 OUT.n1833 OUT.n1832 4.5005
R5897 OUT.n1835 OUT.n1834 4.5005
R5898 OUT.n1839 OUT.n1838 4.5005
R5899 OUT.n1837 OUT.n1836 4.5005
R5900 OUT.n1841 OUT.n1840 4.5005
R5901 OUT.n1843 OUT.n1842 4.5005
R5902 OUT.n1847 OUT.n1846 4.5005
R5903 OUT.n1845 OUT.n1844 4.5005
R5904 OUT.n1851 OUT.n1850 4.5005
R5905 OUT.n1849 OUT.n1848 4.5005
R5906 OUT.n1853 OUT.n1852 4.5005
R5907 OUT.n1855 OUT.n1854 4.5005
R5908 OUT.n1859 OUT.n1858 4.5005
R5909 OUT.n1857 OUT.n1856 4.5005
R5910 OUT.n1861 OUT.n1860 4.5005
R5911 OUT.n1863 OUT.n1862 4.5005
R5912 OUT.n1867 OUT.n1866 4.5005
R5913 OUT.n1865 OUT.n1864 4.5005
R5914 OUT.n1871 OUT.n1870 4.5005
R5915 OUT.n1869 OUT.n1868 4.5005
R5916 OUT.n1873 OUT.n1872 4.5005
R5917 OUT.n1875 OUT.n1874 4.5005
R5918 OUT.n1879 OUT.n1878 4.5005
R5919 OUT.n1877 OUT.n1876 4.5005
R5920 OUT.n1883 OUT.n1882 4.5005
R5921 OUT.n1881 OUT.n1880 4.5005
R5922 OUT.n1887 OUT.n1886 4.5005
R5923 OUT.n1885 OUT.n1884 4.5005
R5924 OUT.n1891 OUT.n1890 4.5005
R5925 OUT.n1889 OUT.n1888 4.5005
R5926 OUT.n1893 OUT.n1892 4.5005
R5927 OUT.n1895 OUT.n1894 4.5005
R5928 OUT.n1899 OUT.n1898 4.5005
R5929 OUT.n1897 OUT.n1896 4.5005
R5930 OUT.n1903 OUT.n1902 4.5005
R5931 OUT.n1901 OUT.n1900 4.5005
R5932 OUT.n1907 OUT.n1906 4.5005
R5933 OUT.n1905 OUT.n1904 4.5005
R5934 OUT.n1911 OUT.n1910 4.5005
R5935 OUT.n1909 OUT.n1908 4.5005
R5936 OUT.n1915 OUT.n1914 4.5005
R5937 OUT.n1913 OUT.n1912 4.5005
R5938 OUT.n1919 OUT.n1918 4.5005
R5939 OUT.n1917 OUT.n1916 4.5005
R5940 OUT.n1923 OUT.n1922 4.5005
R5941 OUT.n1921 OUT.n1920 4.5005
R5942 OUT.n1927 OUT.n1926 4.5005
R5943 OUT.n1925 OUT.n1924 4.5005
R5944 OUT.n1931 OUT.n1930 4.5005
R5945 OUT.n1929 OUT.n1928 4.5005
R5946 OUT.n1933 OUT.n1932 4.5005
R5947 OUT.n1935 OUT.n1934 4.5005
R5948 OUT.n1939 OUT.n1938 4.5005
R5949 OUT.n1937 OUT.n1936 4.5005
R5950 OUT.n1943 OUT.n1942 4.5005
R5951 OUT.n1941 OUT.n1940 4.5005
R5952 OUT.n1947 OUT.n1946 4.5005
R5953 OUT.n1945 OUT.n1944 4.5005
R5954 OUT.n1955 OUT.n1954 4.5005
R5955 OUT.n1953 OUT.n1952 4.5005
R5956 OUT.n1959 OUT.n1958 4.5005
R5957 OUT.n1957 OUT.n1956 4.5005
R5958 OUT.n1961 OUT.n1960 4.5005
R5959 OUT.n1963 OUT.n1962 4.5005
R5960 OUT.n1967 OUT.n1966 4.5005
R5961 OUT.n1965 OUT.n1964 4.5005
R5962 OUT.n1969 OUT.n1968 4.5005
R5963 OUT.n1971 OUT.n1970 4.5005
R5964 OUT.n1975 OUT.n1974 4.5005
R5965 OUT.n1973 OUT.n1972 4.5005
R5966 OUT.n1979 OUT.n1978 4.5005
R5967 OUT.n1977 OUT.n1976 4.5005
R5968 OUT.n1981 OUT.n1980 4.5005
R5969 OUT.n1983 OUT.n1982 4.5005
R5970 OUT.n1987 OUT.n1986 4.5005
R5971 OUT.n1985 OUT.n1984 4.5005
R5972 OUT.n1989 OUT.n1988 4.5005
R5973 OUT.n1991 OUT.n1990 4.5005
R5974 OUT.n1995 OUT.n1994 4.5005
R5975 OUT.n1993 OUT.n1992 4.5005
R5976 OUT.n1999 OUT.n1998 4.5005
R5977 OUT.n1997 OUT.n1996 4.5005
R5978 OUT.n2001 OUT.n2000 4.5005
R5979 OUT.n2003 OUT.n2002 4.5005
R5980 OUT.n2007 OUT.n2006 4.5005
R5981 OUT.n2005 OUT.n2004 4.5005
R5982 OUT.n2011 OUT.n2010 4.5005
R5983 OUT.n2009 OUT.n2008 4.5005
R5984 OUT.n2015 OUT.n2014 4.5005
R5985 OUT.n2013 OUT.n2012 4.5005
R5986 OUT.n2019 OUT.n2018 4.5005
R5987 OUT.n2017 OUT.n2016 4.5005
R5988 OUT.n2021 OUT.n2020 4.5005
R5989 OUT.n2023 OUT.n2022 4.5005
R5990 OUT.n2027 OUT.n2026 4.5005
R5991 OUT.n2025 OUT.n2024 4.5005
R5992 OUT.n2031 OUT.n2030 4.5005
R5993 OUT.n2029 OUT.n2028 4.5005
R5994 OUT.n2035 OUT.n2034 4.5005
R5995 OUT.n2033 OUT.n2032 4.5005
R5996 OUT.n2039 OUT.n2038 4.5005
R5997 OUT.n2037 OUT.n2036 4.5005
R5998 OUT.n2043 OUT.n2042 4.5005
R5999 OUT.n2041 OUT.n2040 4.5005
R6000 OUT.n2047 OUT.n2046 4.5005
R6001 OUT.n2045 OUT.n2044 4.5005
R6002 OUT.n2051 OUT.n2050 4.5005
R6003 OUT.n2049 OUT.n2048 4.5005
R6004 OUT.n2055 OUT.n2054 4.5005
R6005 OUT.n2053 OUT.n2052 4.5005
R6006 OUT.n2059 OUT.n2058 4.5005
R6007 OUT.n2057 OUT.n2056 4.5005
R6008 OUT.n2061 OUT.n2060 4.5005
R6009 OUT.n2063 OUT.n2062 4.5005
R6010 OUT.n2067 OUT.n2066 4.5005
R6011 OUT.n2065 OUT.n2064 4.5005
R6012 OUT.n2071 OUT.n2070 4.5005
R6013 OUT.n2069 OUT.n2068 4.5005
R6014 OUT.n2075 OUT.n2074 4.5005
R6015 OUT.n2073 OUT.n2072 4.5005
R6016 OUT.n2181 OUT.n13 4.26717
R6017 OUT.n270 OUT.n13 4.26717
R6018 OUT.n526 OUT.n270 4.26717
R6019 OUT.n527 OUT.n526 4.26717
R6020 OUT.n534 OUT.n527 4.26717
R6021 OUT.n790 OUT.n534 4.26717
R6022 OUT.n791 OUT.n790 4.26717
R6023 OUT.n792 OUT.n791 4.26717
R6024 OUT.n921 OUT.n792 4.26717
R6025 OUT.n1049 OUT.n921 4.26717
R6026 OUT.n1177 OUT.n1049 4.26717
R6027 OUT.n1306 OUT.n1177 4.26717
R6028 OUT.n1307 OUT.n1306 4.26717
R6029 OUT.n1435 OUT.n1307 4.26717
R6030 OUT.n1563 OUT.n1435 4.26717
R6031 OUT.n1692 OUT.n1563 4.26717
R6032 OUT.n1693 OUT.n1692 4.26717
R6033 OUT.n1822 OUT.n1693 4.26717
R6034 OUT.n1950 OUT.n1822 4.26717
R6035 OUT.n2188 OUT.n2187 3.4105
R6036 OUT.n2187 OUT.n8 3.4105
R6037 OUT.n2193 OUT.n8 3.4105
R6038 OUT.n2190 OUT.n6 3.4105
R6039 OUT.n2193 OUT.n6 3.4105
R6040 OUT.n2193 OUT.n2192 3.4105
R6041 OUT.n2099 OUT.n1562 2.2505
R6042 OUT.n2109 OUT.n1308 2.2505
R6043 OUT.n2115 OUT.n2114 2.2505
R6044 OUT.n2119 OUT.n1176 2.2505
R6045 OUT.n2128 OUT.n2127 2.2505
R6046 OUT.n2136 OUT.n793 2.2505
R6047 OUT.n2150 OUT.n533 2.2505
R6048 OUT.n2155 OUT.n2154 2.2505
R6049 OUT.n2160 OUT.n2159 2.2505
R6050 OUT.n2169 OUT.n2168 2.2505
R6051 OUT.n2178 OUT.n15 2.2505
R6052 OUT.n12 OUT.n11 2.2505
R6053 OUT.n16 OUT.n14 2.2505
R6054 OUT.n2173 OUT.n2172 2.2505
R6055 OUT.n2170 OUT.n143 2.2505
R6056 OUT.n2176 OUT.n2175 2.2505
R6057 OUT.n2163 OUT.n271 2.2505
R6058 OUT.n2166 OUT.n2165 2.2505
R6059 OUT.n2158 OUT.n399 2.2505
R6060 OUT.n2153 OUT.n528 2.2505
R6061 OUT.n2146 OUT.n2145 2.2505
R6062 OUT.n2149 OUT.n2148 2.2505
R6063 OUT.n2141 OUT.n2140 2.2505
R6064 OUT.n2139 OUT.n789 2.2505
R6065 OUT.n2144 OUT.n2143 2.2505
R6066 OUT.n2132 OUT.n2131 2.2505
R6067 OUT.n2129 OUT.n922 2.2505
R6068 OUT.n2135 OUT.n2134 2.2505
R6069 OUT.n2122 OUT.n1050 2.2505
R6070 OUT.n2125 OUT.n2124 2.2505
R6071 OUT.n2118 OUT.n2117 2.2505
R6072 OUT.n2113 OUT.n1305 2.2505
R6073 OUT.n2105 OUT.n2104 2.2505
R6074 OUT.n2108 OUT.n2107 2.2505
R6075 OUT.n2102 OUT.n1436 2.2505
R6076 OUT.n2095 OUT.n2094 2.2505
R6077 OUT.n2093 OUT.n1691 2.2505
R6078 OUT.n2090 OUT.n1694 2.2505
R6079 OUT.n2089 OUT.n2088 2.2505
R6080 OUT.n2087 OUT.n1821 2.2505
R6081 OUT.n2083 OUT.n1823 2.2505
R6082 OUT.n2082 OUT.n2081 2.2505
R6083 OUT.n2098 OUT.n2097 2.2505
R6084 OUT.n2079 OUT.n2078 2.2505
R6085 OUT.n2188 OUT.n7 1.70329
R6086 OUT.n2190 OUT.n2189 1.70329
R6087 OUT.n2186 OUT.n2185 1.70329
R6088 OUT.n2187 OUT.n9 1.70329
R6089 OUT.n2192 OUT.n2191 1.70239
R6090 OUT.n2195 OUT.n2194 1.29941
R6091 OUT.n2194 OUT.n2193 0.912481
R6092 OUT.n2077 OUT.n1951 0.52175
R6093 OUT.n2181 OUT.n2180 0.517167
R6094 OUT.n2174 OUT.n13 0.517167
R6095 OUT.n2167 OUT.n270 0.517167
R6096 OUT.n526 OUT.n398 0.517167
R6097 OUT.n2156 OUT.n527 0.517167
R6098 OUT.n2151 OUT.n534 0.517167
R6099 OUT.n790 OUT.n535 0.517167
R6100 OUT.n791 OUT.n788 0.517167
R6101 OUT.n2138 OUT.n792 0.517167
R6102 OUT.n2133 OUT.n921 0.517167
R6103 OUT.n2126 OUT.n1049 0.517167
R6104 OUT.n2120 OUT.n1177 0.517167
R6105 OUT.n1306 OUT.n1178 0.517167
R6106 OUT.n2112 OUT.n1307 0.517167
R6107 OUT.n2106 OUT.n1435 0.517167
R6108 OUT.n2100 OUT.n1563 0.517167
R6109 OUT.n1692 OUT.n1564 0.517167
R6110 OUT.n2092 OUT.n1693 0.517167
R6111 OUT.n2086 OUT.n1822 0.517167
R6112 OUT.n2080 OUT.n1950 0.517167
R6113 OUT.n2101 OUT.n2100 0.5005
R6114 OUT.n2106 OUT.n1434 0.5005
R6115 OUT.n2112 OUT.n2111 0.5005
R6116 OUT.n2116 OUT.n1178 0.5005
R6117 OUT.n2121 OUT.n2120 0.5005
R6118 OUT.n2126 OUT.n1048 0.5005
R6119 OUT.n2133 OUT.n920 0.5005
R6120 OUT.n2138 OUT.n2137 0.5005
R6121 OUT.n2142 OUT.n788 0.5005
R6122 OUT.n2147 OUT.n535 0.5005
R6123 OUT.n2152 OUT.n2151 0.5005
R6124 OUT.n2157 OUT.n2156 0.5005
R6125 OUT.n2162 OUT.n2161 0.5005
R6126 OUT.n2167 OUT.n269 0.5005
R6127 OUT.n2174 OUT.n142 0.5005
R6128 OUT.n2180 OUT.n2179 0.5005
R6129 OUT.n2096 OUT.n1564 0.5005
R6130 OUT.n2092 OUT.n2091 0.5005
R6131 OUT.n2086 OUT.n2085 0.5005
R6132 OUT.n2080 OUT.n1949 0.5005
R6133 OUT.n2196 OUT.n2 0.446277
R6134 OUT.n2195 OUT.n5 0.446277
R6135 OUT.n2183 OUT.n2182 0.410204
R6136 OUT.n2196 OUT.n2195 0.285348
R6137 OUT.n141 OUT.n140 0.23809
R6138 OUT.n268 OUT.n267 0.23809
R6139 OUT.n396 OUT.n395 0.23809
R6140 OUT.n524 OUT.n523 0.23809
R6141 OUT.n660 OUT.n659 0.23809
R6142 OUT.n786 OUT.n785 0.23809
R6143 OUT.n918 OUT.n917 0.23809
R6144 OUT.n1047 OUT.n1046 0.23809
R6145 OUT.n1175 OUT.n1174 0.23809
R6146 OUT.n1303 OUT.n1302 0.23809
R6147 OUT.n1433 OUT.n1432 0.23809
R6148 OUT.n1561 OUT.n1560 0.23809
R6149 OUT.n1689 OUT.n1688 0.23809
R6150 OUT.n1819 OUT.n1818 0.23809
R6151 OUT.n1948 OUT.n1947 0.23809
R6152 OUT.n2076 OUT.n2075 0.23809
R6153 OUT.n25 OUT.n24 0.21925
R6154 OUT.n33 OUT.n32 0.21925
R6155 OUT.n45 OUT.n44 0.21925
R6156 OUT.n53 OUT.n52 0.21925
R6157 OUT.n65 OUT.n64 0.21925
R6158 OUT.n77 OUT.n76 0.21925
R6159 OUT.n85 OUT.n84 0.21925
R6160 OUT.n101 OUT.n100 0.21925
R6161 OUT.n109 OUT.n108 0.21925
R6162 OUT.n121 OUT.n120 0.21925
R6163 OUT.n125 OUT.n124 0.21925
R6164 OUT.n137 OUT.n136 0.21925
R6165 OUT.n152 OUT.n151 0.21925
R6166 OUT.n160 OUT.n159 0.21925
R6167 OUT.n172 OUT.n171 0.21925
R6168 OUT.n180 OUT.n179 0.21925
R6169 OUT.n192 OUT.n191 0.21925
R6170 OUT.n204 OUT.n203 0.21925
R6171 OUT.n212 OUT.n211 0.21925
R6172 OUT.n228 OUT.n227 0.21925
R6173 OUT.n236 OUT.n235 0.21925
R6174 OUT.n248 OUT.n247 0.21925
R6175 OUT.n252 OUT.n251 0.21925
R6176 OUT.n264 OUT.n263 0.21925
R6177 OUT.n280 OUT.n279 0.21925
R6178 OUT.n288 OUT.n287 0.21925
R6179 OUT.n300 OUT.n299 0.21925
R6180 OUT.n308 OUT.n307 0.21925
R6181 OUT.n320 OUT.n319 0.21925
R6182 OUT.n332 OUT.n331 0.21925
R6183 OUT.n340 OUT.n339 0.21925
R6184 OUT.n356 OUT.n355 0.21925
R6185 OUT.n364 OUT.n363 0.21925
R6186 OUT.n376 OUT.n375 0.21925
R6187 OUT.n380 OUT.n379 0.21925
R6188 OUT.n392 OUT.n391 0.21925
R6189 OUT.n408 OUT.n407 0.21925
R6190 OUT.n416 OUT.n415 0.21925
R6191 OUT.n428 OUT.n427 0.21925
R6192 OUT.n436 OUT.n435 0.21925
R6193 OUT.n448 OUT.n447 0.21925
R6194 OUT.n460 OUT.n459 0.21925
R6195 OUT.n468 OUT.n467 0.21925
R6196 OUT.n484 OUT.n483 0.21925
R6197 OUT.n492 OUT.n491 0.21925
R6198 OUT.n504 OUT.n503 0.21925
R6199 OUT.n508 OUT.n507 0.21925
R6200 OUT.n520 OUT.n519 0.21925
R6201 OUT.n544 OUT.n543 0.21925
R6202 OUT.n552 OUT.n551 0.21925
R6203 OUT.n564 OUT.n563 0.21925
R6204 OUT.n572 OUT.n571 0.21925
R6205 OUT.n584 OUT.n583 0.21925
R6206 OUT.n596 OUT.n595 0.21925
R6207 OUT.n604 OUT.n603 0.21925
R6208 OUT.n620 OUT.n619 0.21925
R6209 OUT.n628 OUT.n627 0.21925
R6210 OUT.n640 OUT.n639 0.21925
R6211 OUT.n644 OUT.n643 0.21925
R6212 OUT.n656 OUT.n655 0.21925
R6213 OUT.n670 OUT.n669 0.21925
R6214 OUT.n678 OUT.n677 0.21925
R6215 OUT.n690 OUT.n689 0.21925
R6216 OUT.n698 OUT.n697 0.21925
R6217 OUT.n710 OUT.n709 0.21925
R6218 OUT.n722 OUT.n721 0.21925
R6219 OUT.n730 OUT.n729 0.21925
R6220 OUT.n746 OUT.n745 0.21925
R6221 OUT.n754 OUT.n753 0.21925
R6222 OUT.n766 OUT.n765 0.21925
R6223 OUT.n770 OUT.n769 0.21925
R6224 OUT.n782 OUT.n781 0.21925
R6225 OUT.n802 OUT.n801 0.21925
R6226 OUT.n810 OUT.n809 0.21925
R6227 OUT.n822 OUT.n821 0.21925
R6228 OUT.n830 OUT.n829 0.21925
R6229 OUT.n842 OUT.n841 0.21925
R6230 OUT.n854 OUT.n853 0.21925
R6231 OUT.n862 OUT.n861 0.21925
R6232 OUT.n878 OUT.n877 0.21925
R6233 OUT.n886 OUT.n885 0.21925
R6234 OUT.n898 OUT.n897 0.21925
R6235 OUT.n902 OUT.n901 0.21925
R6236 OUT.n914 OUT.n913 0.21925
R6237 OUT.n931 OUT.n930 0.21925
R6238 OUT.n939 OUT.n938 0.21925
R6239 OUT.n951 OUT.n950 0.21925
R6240 OUT.n959 OUT.n958 0.21925
R6241 OUT.n971 OUT.n970 0.21925
R6242 OUT.n983 OUT.n982 0.21925
R6243 OUT.n991 OUT.n990 0.21925
R6244 OUT.n1007 OUT.n1006 0.21925
R6245 OUT.n1015 OUT.n1014 0.21925
R6246 OUT.n1027 OUT.n1026 0.21925
R6247 OUT.n1031 OUT.n1030 0.21925
R6248 OUT.n1043 OUT.n1042 0.21925
R6249 OUT.n1059 OUT.n1058 0.21925
R6250 OUT.n1067 OUT.n1066 0.21925
R6251 OUT.n1079 OUT.n1078 0.21925
R6252 OUT.n1087 OUT.n1086 0.21925
R6253 OUT.n1099 OUT.n1098 0.21925
R6254 OUT.n1111 OUT.n1110 0.21925
R6255 OUT.n1119 OUT.n1118 0.21925
R6256 OUT.n1135 OUT.n1134 0.21925
R6257 OUT.n1143 OUT.n1142 0.21925
R6258 OUT.n1155 OUT.n1154 0.21925
R6259 OUT.n1159 OUT.n1158 0.21925
R6260 OUT.n1171 OUT.n1170 0.21925
R6261 OUT.n1187 OUT.n1186 0.21925
R6262 OUT.n1195 OUT.n1194 0.21925
R6263 OUT.n1207 OUT.n1206 0.21925
R6264 OUT.n1215 OUT.n1214 0.21925
R6265 OUT.n1227 OUT.n1226 0.21925
R6266 OUT.n1239 OUT.n1238 0.21925
R6267 OUT.n1247 OUT.n1246 0.21925
R6268 OUT.n1263 OUT.n1262 0.21925
R6269 OUT.n1271 OUT.n1270 0.21925
R6270 OUT.n1283 OUT.n1282 0.21925
R6271 OUT.n1287 OUT.n1286 0.21925
R6272 OUT.n1299 OUT.n1298 0.21925
R6273 OUT.n1317 OUT.n1316 0.21925
R6274 OUT.n1325 OUT.n1324 0.21925
R6275 OUT.n1337 OUT.n1336 0.21925
R6276 OUT.n1345 OUT.n1344 0.21925
R6277 OUT.n1357 OUT.n1356 0.21925
R6278 OUT.n1369 OUT.n1368 0.21925
R6279 OUT.n1377 OUT.n1376 0.21925
R6280 OUT.n1393 OUT.n1392 0.21925
R6281 OUT.n1401 OUT.n1400 0.21925
R6282 OUT.n1413 OUT.n1412 0.21925
R6283 OUT.n1417 OUT.n1416 0.21925
R6284 OUT.n1429 OUT.n1428 0.21925
R6285 OUT.n1445 OUT.n1444 0.21925
R6286 OUT.n1453 OUT.n1452 0.21925
R6287 OUT.n1465 OUT.n1464 0.21925
R6288 OUT.n1473 OUT.n1472 0.21925
R6289 OUT.n1485 OUT.n1484 0.21925
R6290 OUT.n1497 OUT.n1496 0.21925
R6291 OUT.n1505 OUT.n1504 0.21925
R6292 OUT.n1521 OUT.n1520 0.21925
R6293 OUT.n1529 OUT.n1528 0.21925
R6294 OUT.n1541 OUT.n1540 0.21925
R6295 OUT.n1545 OUT.n1544 0.21925
R6296 OUT.n1557 OUT.n1556 0.21925
R6297 OUT.n1573 OUT.n1572 0.21925
R6298 OUT.n1581 OUT.n1580 0.21925
R6299 OUT.n1593 OUT.n1592 0.21925
R6300 OUT.n1601 OUT.n1600 0.21925
R6301 OUT.n1613 OUT.n1612 0.21925
R6302 OUT.n1625 OUT.n1624 0.21925
R6303 OUT.n1633 OUT.n1632 0.21925
R6304 OUT.n1649 OUT.n1648 0.21925
R6305 OUT.n1657 OUT.n1656 0.21925
R6306 OUT.n1669 OUT.n1668 0.21925
R6307 OUT.n1673 OUT.n1672 0.21925
R6308 OUT.n1685 OUT.n1684 0.21925
R6309 OUT.n1703 OUT.n1702 0.21925
R6310 OUT.n1711 OUT.n1710 0.21925
R6311 OUT.n1723 OUT.n1722 0.21925
R6312 OUT.n1731 OUT.n1730 0.21925
R6313 OUT.n1743 OUT.n1742 0.21925
R6314 OUT.n1755 OUT.n1754 0.21925
R6315 OUT.n1763 OUT.n1762 0.21925
R6316 OUT.n1779 OUT.n1778 0.21925
R6317 OUT.n1787 OUT.n1786 0.21925
R6318 OUT.n1799 OUT.n1798 0.21925
R6319 OUT.n1803 OUT.n1802 0.21925
R6320 OUT.n1815 OUT.n1814 0.21925
R6321 OUT.n1832 OUT.n1831 0.21925
R6322 OUT.n1840 OUT.n1839 0.21925
R6323 OUT.n1852 OUT.n1851 0.21925
R6324 OUT.n1860 OUT.n1859 0.21925
R6325 OUT.n1872 OUT.n1871 0.21925
R6326 OUT.n1884 OUT.n1883 0.21925
R6327 OUT.n1892 OUT.n1891 0.21925
R6328 OUT.n1908 OUT.n1907 0.21925
R6329 OUT.n1916 OUT.n1915 0.21925
R6330 OUT.n1928 OUT.n1927 0.21925
R6331 OUT.n1932 OUT.n1931 0.21925
R6332 OUT.n1944 OUT.n1943 0.21925
R6333 OUT.n1960 OUT.n1959 0.21925
R6334 OUT.n1968 OUT.n1967 0.21925
R6335 OUT.n1980 OUT.n1979 0.21925
R6336 OUT.n1988 OUT.n1987 0.21925
R6337 OUT.n2000 OUT.n1999 0.21925
R6338 OUT.n2012 OUT.n2011 0.21925
R6339 OUT.n2020 OUT.n2019 0.21925
R6340 OUT.n2036 OUT.n2035 0.21925
R6341 OUT.n2044 OUT.n2043 0.21925
R6342 OUT.n2056 OUT.n2055 0.21925
R6343 OUT.n2060 OUT.n2059 0.21925
R6344 OUT.n2072 OUT.n2071 0.21925
R6345 OUT.n21 OUT.n20 0.213
R6346 OUT.n29 OUT.n28 0.213
R6347 OUT.n37 OUT.n36 0.213
R6348 OUT.n41 OUT.n40 0.213
R6349 OUT.n49 OUT.n48 0.213
R6350 OUT.n57 OUT.n56 0.213
R6351 OUT.n61 OUT.n60 0.213
R6352 OUT.n69 OUT.n68 0.213
R6353 OUT.n73 OUT.n72 0.213
R6354 OUT.n81 OUT.n80 0.213
R6355 OUT.n89 OUT.n88 0.213
R6356 OUT.n93 OUT.n92 0.213
R6357 OUT.n97 OUT.n96 0.213
R6358 OUT.n105 OUT.n104 0.213
R6359 OUT.n113 OUT.n112 0.213
R6360 OUT.n117 OUT.n116 0.213
R6361 OUT.n129 OUT.n128 0.213
R6362 OUT.n133 OUT.n132 0.213
R6363 OUT.n148 OUT.n147 0.213
R6364 OUT.n156 OUT.n155 0.213
R6365 OUT.n164 OUT.n163 0.213
R6366 OUT.n168 OUT.n167 0.213
R6367 OUT.n176 OUT.n175 0.213
R6368 OUT.n184 OUT.n183 0.213
R6369 OUT.n188 OUT.n187 0.213
R6370 OUT.n196 OUT.n195 0.213
R6371 OUT.n200 OUT.n199 0.213
R6372 OUT.n208 OUT.n207 0.213
R6373 OUT.n216 OUT.n215 0.213
R6374 OUT.n220 OUT.n219 0.213
R6375 OUT.n224 OUT.n223 0.213
R6376 OUT.n232 OUT.n231 0.213
R6377 OUT.n240 OUT.n239 0.213
R6378 OUT.n244 OUT.n243 0.213
R6379 OUT.n256 OUT.n255 0.213
R6380 OUT.n260 OUT.n259 0.213
R6381 OUT.n276 OUT.n275 0.213
R6382 OUT.n284 OUT.n283 0.213
R6383 OUT.n292 OUT.n291 0.213
R6384 OUT.n296 OUT.n295 0.213
R6385 OUT.n304 OUT.n303 0.213
R6386 OUT.n312 OUT.n311 0.213
R6387 OUT.n316 OUT.n315 0.213
R6388 OUT.n324 OUT.n323 0.213
R6389 OUT.n328 OUT.n327 0.213
R6390 OUT.n336 OUT.n335 0.213
R6391 OUT.n344 OUT.n343 0.213
R6392 OUT.n348 OUT.n347 0.213
R6393 OUT.n352 OUT.n351 0.213
R6394 OUT.n360 OUT.n359 0.213
R6395 OUT.n368 OUT.n367 0.213
R6396 OUT.n372 OUT.n371 0.213
R6397 OUT.n384 OUT.n383 0.213
R6398 OUT.n388 OUT.n387 0.213
R6399 OUT.n404 OUT.n403 0.213
R6400 OUT.n412 OUT.n411 0.213
R6401 OUT.n420 OUT.n419 0.213
R6402 OUT.n424 OUT.n423 0.213
R6403 OUT.n432 OUT.n431 0.213
R6404 OUT.n440 OUT.n439 0.213
R6405 OUT.n444 OUT.n443 0.213
R6406 OUT.n452 OUT.n451 0.213
R6407 OUT.n456 OUT.n455 0.213
R6408 OUT.n464 OUT.n463 0.213
R6409 OUT.n472 OUT.n471 0.213
R6410 OUT.n476 OUT.n475 0.213
R6411 OUT.n480 OUT.n479 0.213
R6412 OUT.n488 OUT.n487 0.213
R6413 OUT.n496 OUT.n495 0.213
R6414 OUT.n500 OUT.n499 0.213
R6415 OUT.n512 OUT.n511 0.213
R6416 OUT.n516 OUT.n515 0.213
R6417 OUT.n540 OUT.n539 0.213
R6418 OUT.n548 OUT.n547 0.213
R6419 OUT.n556 OUT.n555 0.213
R6420 OUT.n560 OUT.n559 0.213
R6421 OUT.n568 OUT.n567 0.213
R6422 OUT.n576 OUT.n575 0.213
R6423 OUT.n580 OUT.n579 0.213
R6424 OUT.n588 OUT.n587 0.213
R6425 OUT.n592 OUT.n591 0.213
R6426 OUT.n600 OUT.n599 0.213
R6427 OUT.n608 OUT.n607 0.213
R6428 OUT.n612 OUT.n611 0.213
R6429 OUT.n616 OUT.n615 0.213
R6430 OUT.n624 OUT.n623 0.213
R6431 OUT.n632 OUT.n631 0.213
R6432 OUT.n636 OUT.n635 0.213
R6433 OUT.n648 OUT.n647 0.213
R6434 OUT.n652 OUT.n651 0.213
R6435 OUT.n666 OUT.n665 0.213
R6436 OUT.n674 OUT.n673 0.213
R6437 OUT.n682 OUT.n681 0.213
R6438 OUT.n686 OUT.n685 0.213
R6439 OUT.n694 OUT.n693 0.213
R6440 OUT.n702 OUT.n701 0.213
R6441 OUT.n706 OUT.n705 0.213
R6442 OUT.n714 OUT.n713 0.213
R6443 OUT.n718 OUT.n717 0.213
R6444 OUT.n726 OUT.n725 0.213
R6445 OUT.n734 OUT.n733 0.213
R6446 OUT.n738 OUT.n737 0.213
R6447 OUT.n742 OUT.n741 0.213
R6448 OUT.n750 OUT.n749 0.213
R6449 OUT.n758 OUT.n757 0.213
R6450 OUT.n762 OUT.n761 0.213
R6451 OUT.n774 OUT.n773 0.213
R6452 OUT.n778 OUT.n777 0.213
R6453 OUT.n798 OUT.n797 0.213
R6454 OUT.n806 OUT.n805 0.213
R6455 OUT.n814 OUT.n813 0.213
R6456 OUT.n818 OUT.n817 0.213
R6457 OUT.n826 OUT.n825 0.213
R6458 OUT.n834 OUT.n833 0.213
R6459 OUT.n838 OUT.n837 0.213
R6460 OUT.n846 OUT.n845 0.213
R6461 OUT.n850 OUT.n849 0.213
R6462 OUT.n858 OUT.n857 0.213
R6463 OUT.n866 OUT.n865 0.213
R6464 OUT.n870 OUT.n869 0.213
R6465 OUT.n874 OUT.n873 0.213
R6466 OUT.n882 OUT.n881 0.213
R6467 OUT.n890 OUT.n889 0.213
R6468 OUT.n894 OUT.n893 0.213
R6469 OUT.n906 OUT.n905 0.213
R6470 OUT.n910 OUT.n909 0.213
R6471 OUT.n927 OUT.n926 0.213
R6472 OUT.n935 OUT.n934 0.213
R6473 OUT.n943 OUT.n942 0.213
R6474 OUT.n947 OUT.n946 0.213
R6475 OUT.n955 OUT.n954 0.213
R6476 OUT.n963 OUT.n962 0.213
R6477 OUT.n967 OUT.n966 0.213
R6478 OUT.n975 OUT.n974 0.213
R6479 OUT.n979 OUT.n978 0.213
R6480 OUT.n987 OUT.n986 0.213
R6481 OUT.n995 OUT.n994 0.213
R6482 OUT.n999 OUT.n998 0.213
R6483 OUT.n1003 OUT.n1002 0.213
R6484 OUT.n1011 OUT.n1010 0.213
R6485 OUT.n1019 OUT.n1018 0.213
R6486 OUT.n1023 OUT.n1022 0.213
R6487 OUT.n1035 OUT.n1034 0.213
R6488 OUT.n1039 OUT.n1038 0.213
R6489 OUT.n1055 OUT.n1054 0.213
R6490 OUT.n1063 OUT.n1062 0.213
R6491 OUT.n1071 OUT.n1070 0.213
R6492 OUT.n1075 OUT.n1074 0.213
R6493 OUT.n1083 OUT.n1082 0.213
R6494 OUT.n1091 OUT.n1090 0.213
R6495 OUT.n1095 OUT.n1094 0.213
R6496 OUT.n1103 OUT.n1102 0.213
R6497 OUT.n1107 OUT.n1106 0.213
R6498 OUT.n1115 OUT.n1114 0.213
R6499 OUT.n1123 OUT.n1122 0.213
R6500 OUT.n1127 OUT.n1126 0.213
R6501 OUT.n1131 OUT.n1130 0.213
R6502 OUT.n1139 OUT.n1138 0.213
R6503 OUT.n1147 OUT.n1146 0.213
R6504 OUT.n1151 OUT.n1150 0.213
R6505 OUT.n1163 OUT.n1162 0.213
R6506 OUT.n1167 OUT.n1166 0.213
R6507 OUT.n1183 OUT.n1182 0.213
R6508 OUT.n1191 OUT.n1190 0.213
R6509 OUT.n1199 OUT.n1198 0.213
R6510 OUT.n1203 OUT.n1202 0.213
R6511 OUT.n1211 OUT.n1210 0.213
R6512 OUT.n1219 OUT.n1218 0.213
R6513 OUT.n1223 OUT.n1222 0.213
R6514 OUT.n1231 OUT.n1230 0.213
R6515 OUT.n1235 OUT.n1234 0.213
R6516 OUT.n1243 OUT.n1242 0.213
R6517 OUT.n1251 OUT.n1250 0.213
R6518 OUT.n1255 OUT.n1254 0.213
R6519 OUT.n1259 OUT.n1258 0.213
R6520 OUT.n1267 OUT.n1266 0.213
R6521 OUT.n1275 OUT.n1274 0.213
R6522 OUT.n1279 OUT.n1278 0.213
R6523 OUT.n1291 OUT.n1290 0.213
R6524 OUT.n1295 OUT.n1294 0.213
R6525 OUT.n1313 OUT.n1312 0.213
R6526 OUT.n1321 OUT.n1320 0.213
R6527 OUT.n1329 OUT.n1328 0.213
R6528 OUT.n1333 OUT.n1332 0.213
R6529 OUT.n1341 OUT.n1340 0.213
R6530 OUT.n1349 OUT.n1348 0.213
R6531 OUT.n1353 OUT.n1352 0.213
R6532 OUT.n1361 OUT.n1360 0.213
R6533 OUT.n1365 OUT.n1364 0.213
R6534 OUT.n1373 OUT.n1372 0.213
R6535 OUT.n1381 OUT.n1380 0.213
R6536 OUT.n1385 OUT.n1384 0.213
R6537 OUT.n1389 OUT.n1388 0.213
R6538 OUT.n1397 OUT.n1396 0.213
R6539 OUT.n1405 OUT.n1404 0.213
R6540 OUT.n1409 OUT.n1408 0.213
R6541 OUT.n1421 OUT.n1420 0.213
R6542 OUT.n1425 OUT.n1424 0.213
R6543 OUT.n1441 OUT.n1440 0.213
R6544 OUT.n1449 OUT.n1448 0.213
R6545 OUT.n1457 OUT.n1456 0.213
R6546 OUT.n1461 OUT.n1460 0.213
R6547 OUT.n1469 OUT.n1468 0.213
R6548 OUT.n1477 OUT.n1476 0.213
R6549 OUT.n1481 OUT.n1480 0.213
R6550 OUT.n1489 OUT.n1488 0.213
R6551 OUT.n1493 OUT.n1492 0.213
R6552 OUT.n1501 OUT.n1500 0.213
R6553 OUT.n1509 OUT.n1508 0.213
R6554 OUT.n1513 OUT.n1512 0.213
R6555 OUT.n1517 OUT.n1516 0.213
R6556 OUT.n1525 OUT.n1524 0.213
R6557 OUT.n1533 OUT.n1532 0.213
R6558 OUT.n1537 OUT.n1536 0.213
R6559 OUT.n1549 OUT.n1548 0.213
R6560 OUT.n1553 OUT.n1552 0.213
R6561 OUT.n1569 OUT.n1568 0.213
R6562 OUT.n1577 OUT.n1576 0.213
R6563 OUT.n1585 OUT.n1584 0.213
R6564 OUT.n1589 OUT.n1588 0.213
R6565 OUT.n1597 OUT.n1596 0.213
R6566 OUT.n1605 OUT.n1604 0.213
R6567 OUT.n1609 OUT.n1608 0.213
R6568 OUT.n1617 OUT.n1616 0.213
R6569 OUT.n1621 OUT.n1620 0.213
R6570 OUT.n1629 OUT.n1628 0.213
R6571 OUT.n1637 OUT.n1636 0.213
R6572 OUT.n1641 OUT.n1640 0.213
R6573 OUT.n1645 OUT.n1644 0.213
R6574 OUT.n1653 OUT.n1652 0.213
R6575 OUT.n1661 OUT.n1660 0.213
R6576 OUT.n1665 OUT.n1664 0.213
R6577 OUT.n1677 OUT.n1676 0.213
R6578 OUT.n1681 OUT.n1680 0.213
R6579 OUT.n1699 OUT.n1698 0.213
R6580 OUT.n1707 OUT.n1706 0.213
R6581 OUT.n1715 OUT.n1714 0.213
R6582 OUT.n1719 OUT.n1718 0.213
R6583 OUT.n1727 OUT.n1726 0.213
R6584 OUT.n1735 OUT.n1734 0.213
R6585 OUT.n1739 OUT.n1738 0.213
R6586 OUT.n1747 OUT.n1746 0.213
R6587 OUT.n1751 OUT.n1750 0.213
R6588 OUT.n1759 OUT.n1758 0.213
R6589 OUT.n1767 OUT.n1766 0.213
R6590 OUT.n1771 OUT.n1770 0.213
R6591 OUT.n1775 OUT.n1774 0.213
R6592 OUT.n1783 OUT.n1782 0.213
R6593 OUT.n1791 OUT.n1790 0.213
R6594 OUT.n1795 OUT.n1794 0.213
R6595 OUT.n1807 OUT.n1806 0.213
R6596 OUT.n1811 OUT.n1810 0.213
R6597 OUT.n1828 OUT.n1827 0.213
R6598 OUT.n1836 OUT.n1835 0.213
R6599 OUT.n1844 OUT.n1843 0.213
R6600 OUT.n1848 OUT.n1847 0.213
R6601 OUT.n1856 OUT.n1855 0.213
R6602 OUT.n1864 OUT.n1863 0.213
R6603 OUT.n1868 OUT.n1867 0.213
R6604 OUT.n1876 OUT.n1875 0.213
R6605 OUT.n1880 OUT.n1879 0.213
R6606 OUT.n1888 OUT.n1887 0.213
R6607 OUT.n1896 OUT.n1895 0.213
R6608 OUT.n1900 OUT.n1899 0.213
R6609 OUT.n1904 OUT.n1903 0.213
R6610 OUT.n1912 OUT.n1911 0.213
R6611 OUT.n1920 OUT.n1919 0.213
R6612 OUT.n1924 OUT.n1923 0.213
R6613 OUT.n1936 OUT.n1935 0.213
R6614 OUT.n1940 OUT.n1939 0.213
R6615 OUT.n1956 OUT.n1955 0.213
R6616 OUT.n1964 OUT.n1963 0.213
R6617 OUT.n1972 OUT.n1971 0.213
R6618 OUT.n1976 OUT.n1975 0.213
R6619 OUT.n1984 OUT.n1983 0.213
R6620 OUT.n1992 OUT.n1991 0.213
R6621 OUT.n1996 OUT.n1995 0.213
R6622 OUT.n2004 OUT.n2003 0.213
R6623 OUT.n2008 OUT.n2007 0.213
R6624 OUT.n2016 OUT.n2015 0.213
R6625 OUT.n2024 OUT.n2023 0.213
R6626 OUT.n2028 OUT.n2027 0.213
R6627 OUT.n2032 OUT.n2031 0.213
R6628 OUT.n2040 OUT.n2039 0.213
R6629 OUT.n2048 OUT.n2047 0.213
R6630 OUT.n2052 OUT.n2051 0.213
R6631 OUT.n2064 OUT.n2063 0.213
R6632 OUT.n2068 OUT.n2067 0.213
R6633 OUT.n532 OUT.n531 0.143668
R6634 OUT.n2192 OUT.n2184 0.13909
R6635 OUT.n2184 OUT.n2183 0.129854
R6636 OUT.n531 OUT.n397 0.126796
R6637 OUT.n2179 OUT.n10 0.126796
R6638 OUT.n529 OUT.n142 0.126796
R6639 OUT.n530 OUT.n269 0.126796
R6640 OUT OUT.n2197 0.105162
R6641 OUT.n139 OUT.n138 0.1005
R6642 OUT.n135 OUT.n134 0.1005
R6643 OUT.n131 OUT.n130 0.1005
R6644 OUT.n127 OUT.n126 0.1005
R6645 OUT.n123 OUT.n122 0.1005
R6646 OUT.n119 OUT.n118 0.1005
R6647 OUT.n115 OUT.n114 0.1005
R6648 OUT.n111 OUT.n110 0.1005
R6649 OUT.n107 OUT.n106 0.1005
R6650 OUT.n103 OUT.n102 0.1005
R6651 OUT.n99 OUT.n98 0.1005
R6652 OUT.n95 OUT.n94 0.1005
R6653 OUT.n91 OUT.n90 0.1005
R6654 OUT.n87 OUT.n86 0.1005
R6655 OUT.n83 OUT.n82 0.1005
R6656 OUT.n79 OUT.n78 0.1005
R6657 OUT.n75 OUT.n74 0.1005
R6658 OUT.n71 OUT.n70 0.1005
R6659 OUT.n67 OUT.n66 0.1005
R6660 OUT.n63 OUT.n62 0.1005
R6661 OUT.n59 OUT.n58 0.1005
R6662 OUT.n55 OUT.n54 0.1005
R6663 OUT.n51 OUT.n50 0.1005
R6664 OUT.n47 OUT.n46 0.1005
R6665 OUT.n43 OUT.n42 0.1005
R6666 OUT.n19 OUT.n18 0.1005
R6667 OUT.n266 OUT.n265 0.1005
R6668 OUT.n262 OUT.n261 0.1005
R6669 OUT.n258 OUT.n257 0.1005
R6670 OUT.n254 OUT.n253 0.1005
R6671 OUT.n250 OUT.n249 0.1005
R6672 OUT.n246 OUT.n245 0.1005
R6673 OUT.n242 OUT.n241 0.1005
R6674 OUT.n238 OUT.n237 0.1005
R6675 OUT.n234 OUT.n233 0.1005
R6676 OUT.n230 OUT.n229 0.1005
R6677 OUT.n226 OUT.n225 0.1005
R6678 OUT.n222 OUT.n221 0.1005
R6679 OUT.n218 OUT.n217 0.1005
R6680 OUT.n214 OUT.n213 0.1005
R6681 OUT.n210 OUT.n209 0.1005
R6682 OUT.n206 OUT.n205 0.1005
R6683 OUT.n202 OUT.n201 0.1005
R6684 OUT.n198 OUT.n197 0.1005
R6685 OUT.n194 OUT.n193 0.1005
R6686 OUT.n190 OUT.n189 0.1005
R6687 OUT.n186 OUT.n185 0.1005
R6688 OUT.n182 OUT.n181 0.1005
R6689 OUT.n178 OUT.n177 0.1005
R6690 OUT.n174 OUT.n173 0.1005
R6691 OUT.n170 OUT.n169 0.1005
R6692 OUT.n146 OUT.n145 0.1005
R6693 OUT.n394 OUT.n393 0.1005
R6694 OUT.n390 OUT.n389 0.1005
R6695 OUT.n386 OUT.n385 0.1005
R6696 OUT.n382 OUT.n381 0.1005
R6697 OUT.n378 OUT.n377 0.1005
R6698 OUT.n374 OUT.n373 0.1005
R6699 OUT.n370 OUT.n369 0.1005
R6700 OUT.n366 OUT.n365 0.1005
R6701 OUT.n362 OUT.n361 0.1005
R6702 OUT.n358 OUT.n357 0.1005
R6703 OUT.n354 OUT.n353 0.1005
R6704 OUT.n350 OUT.n349 0.1005
R6705 OUT.n346 OUT.n345 0.1005
R6706 OUT.n342 OUT.n341 0.1005
R6707 OUT.n338 OUT.n337 0.1005
R6708 OUT.n334 OUT.n333 0.1005
R6709 OUT.n330 OUT.n329 0.1005
R6710 OUT.n326 OUT.n325 0.1005
R6711 OUT.n322 OUT.n321 0.1005
R6712 OUT.n318 OUT.n317 0.1005
R6713 OUT.n314 OUT.n313 0.1005
R6714 OUT.n310 OUT.n309 0.1005
R6715 OUT.n306 OUT.n305 0.1005
R6716 OUT.n302 OUT.n301 0.1005
R6717 OUT.n298 OUT.n297 0.1005
R6718 OUT.n274 OUT.n273 0.1005
R6719 OUT.n522 OUT.n521 0.1005
R6720 OUT.n518 OUT.n517 0.1005
R6721 OUT.n514 OUT.n513 0.1005
R6722 OUT.n510 OUT.n509 0.1005
R6723 OUT.n506 OUT.n505 0.1005
R6724 OUT.n502 OUT.n501 0.1005
R6725 OUT.n498 OUT.n497 0.1005
R6726 OUT.n494 OUT.n493 0.1005
R6727 OUT.n490 OUT.n489 0.1005
R6728 OUT.n486 OUT.n485 0.1005
R6729 OUT.n482 OUT.n481 0.1005
R6730 OUT.n478 OUT.n477 0.1005
R6731 OUT.n474 OUT.n473 0.1005
R6732 OUT.n470 OUT.n469 0.1005
R6733 OUT.n466 OUT.n465 0.1005
R6734 OUT.n462 OUT.n461 0.1005
R6735 OUT.n458 OUT.n457 0.1005
R6736 OUT.n454 OUT.n453 0.1005
R6737 OUT.n450 OUT.n449 0.1005
R6738 OUT.n446 OUT.n445 0.1005
R6739 OUT.n442 OUT.n441 0.1005
R6740 OUT.n438 OUT.n437 0.1005
R6741 OUT.n434 OUT.n433 0.1005
R6742 OUT.n430 OUT.n429 0.1005
R6743 OUT.n426 OUT.n425 0.1005
R6744 OUT.n402 OUT.n401 0.1005
R6745 OUT.n658 OUT.n657 0.1005
R6746 OUT.n654 OUT.n653 0.1005
R6747 OUT.n650 OUT.n649 0.1005
R6748 OUT.n646 OUT.n645 0.1005
R6749 OUT.n642 OUT.n641 0.1005
R6750 OUT.n638 OUT.n637 0.1005
R6751 OUT.n634 OUT.n633 0.1005
R6752 OUT.n630 OUT.n629 0.1005
R6753 OUT.n626 OUT.n625 0.1005
R6754 OUT.n622 OUT.n621 0.1005
R6755 OUT.n618 OUT.n617 0.1005
R6756 OUT.n614 OUT.n613 0.1005
R6757 OUT.n610 OUT.n609 0.1005
R6758 OUT.n606 OUT.n605 0.1005
R6759 OUT.n602 OUT.n601 0.1005
R6760 OUT.n598 OUT.n597 0.1005
R6761 OUT.n594 OUT.n593 0.1005
R6762 OUT.n590 OUT.n589 0.1005
R6763 OUT.n586 OUT.n585 0.1005
R6764 OUT.n582 OUT.n581 0.1005
R6765 OUT.n578 OUT.n577 0.1005
R6766 OUT.n574 OUT.n573 0.1005
R6767 OUT.n570 OUT.n569 0.1005
R6768 OUT.n566 OUT.n565 0.1005
R6769 OUT.n562 OUT.n561 0.1005
R6770 OUT.n538 OUT.n537 0.1005
R6771 OUT.n784 OUT.n783 0.1005
R6772 OUT.n780 OUT.n779 0.1005
R6773 OUT.n776 OUT.n775 0.1005
R6774 OUT.n772 OUT.n771 0.1005
R6775 OUT.n768 OUT.n767 0.1005
R6776 OUT.n764 OUT.n763 0.1005
R6777 OUT.n760 OUT.n759 0.1005
R6778 OUT.n756 OUT.n755 0.1005
R6779 OUT.n752 OUT.n751 0.1005
R6780 OUT.n748 OUT.n747 0.1005
R6781 OUT.n744 OUT.n743 0.1005
R6782 OUT.n740 OUT.n739 0.1005
R6783 OUT.n736 OUT.n735 0.1005
R6784 OUT.n732 OUT.n731 0.1005
R6785 OUT.n728 OUT.n727 0.1005
R6786 OUT.n724 OUT.n723 0.1005
R6787 OUT.n720 OUT.n719 0.1005
R6788 OUT.n716 OUT.n715 0.1005
R6789 OUT.n712 OUT.n711 0.1005
R6790 OUT.n708 OUT.n707 0.1005
R6791 OUT.n704 OUT.n703 0.1005
R6792 OUT.n700 OUT.n699 0.1005
R6793 OUT.n696 OUT.n695 0.1005
R6794 OUT.n692 OUT.n691 0.1005
R6795 OUT.n688 OUT.n687 0.1005
R6796 OUT.n664 OUT.n663 0.1005
R6797 OUT.n916 OUT.n915 0.1005
R6798 OUT.n912 OUT.n911 0.1005
R6799 OUT.n908 OUT.n907 0.1005
R6800 OUT.n904 OUT.n903 0.1005
R6801 OUT.n900 OUT.n899 0.1005
R6802 OUT.n896 OUT.n895 0.1005
R6803 OUT.n892 OUT.n891 0.1005
R6804 OUT.n888 OUT.n887 0.1005
R6805 OUT.n884 OUT.n883 0.1005
R6806 OUT.n880 OUT.n879 0.1005
R6807 OUT.n876 OUT.n875 0.1005
R6808 OUT.n872 OUT.n871 0.1005
R6809 OUT.n868 OUT.n867 0.1005
R6810 OUT.n864 OUT.n863 0.1005
R6811 OUT.n860 OUT.n859 0.1005
R6812 OUT.n856 OUT.n855 0.1005
R6813 OUT.n852 OUT.n851 0.1005
R6814 OUT.n848 OUT.n847 0.1005
R6815 OUT.n844 OUT.n843 0.1005
R6816 OUT.n840 OUT.n839 0.1005
R6817 OUT.n836 OUT.n835 0.1005
R6818 OUT.n832 OUT.n831 0.1005
R6819 OUT.n828 OUT.n827 0.1005
R6820 OUT.n824 OUT.n823 0.1005
R6821 OUT.n820 OUT.n819 0.1005
R6822 OUT.n796 OUT.n795 0.1005
R6823 OUT.n1045 OUT.n1044 0.1005
R6824 OUT.n1041 OUT.n1040 0.1005
R6825 OUT.n1037 OUT.n1036 0.1005
R6826 OUT.n1033 OUT.n1032 0.1005
R6827 OUT.n1029 OUT.n1028 0.1005
R6828 OUT.n1025 OUT.n1024 0.1005
R6829 OUT.n1021 OUT.n1020 0.1005
R6830 OUT.n1017 OUT.n1016 0.1005
R6831 OUT.n1013 OUT.n1012 0.1005
R6832 OUT.n1009 OUT.n1008 0.1005
R6833 OUT.n1005 OUT.n1004 0.1005
R6834 OUT.n1001 OUT.n1000 0.1005
R6835 OUT.n997 OUT.n996 0.1005
R6836 OUT.n993 OUT.n992 0.1005
R6837 OUT.n989 OUT.n988 0.1005
R6838 OUT.n985 OUT.n984 0.1005
R6839 OUT.n981 OUT.n980 0.1005
R6840 OUT.n977 OUT.n976 0.1005
R6841 OUT.n973 OUT.n972 0.1005
R6842 OUT.n969 OUT.n968 0.1005
R6843 OUT.n965 OUT.n964 0.1005
R6844 OUT.n961 OUT.n960 0.1005
R6845 OUT.n957 OUT.n956 0.1005
R6846 OUT.n953 OUT.n952 0.1005
R6847 OUT.n949 OUT.n948 0.1005
R6848 OUT.n925 OUT.n924 0.1005
R6849 OUT.n1173 OUT.n1172 0.1005
R6850 OUT.n1169 OUT.n1168 0.1005
R6851 OUT.n1165 OUT.n1164 0.1005
R6852 OUT.n1161 OUT.n1160 0.1005
R6853 OUT.n1157 OUT.n1156 0.1005
R6854 OUT.n1153 OUT.n1152 0.1005
R6855 OUT.n1149 OUT.n1148 0.1005
R6856 OUT.n1145 OUT.n1144 0.1005
R6857 OUT.n1141 OUT.n1140 0.1005
R6858 OUT.n1137 OUT.n1136 0.1005
R6859 OUT.n1133 OUT.n1132 0.1005
R6860 OUT.n1129 OUT.n1128 0.1005
R6861 OUT.n1125 OUT.n1124 0.1005
R6862 OUT.n1121 OUT.n1120 0.1005
R6863 OUT.n1117 OUT.n1116 0.1005
R6864 OUT.n1113 OUT.n1112 0.1005
R6865 OUT.n1109 OUT.n1108 0.1005
R6866 OUT.n1105 OUT.n1104 0.1005
R6867 OUT.n1101 OUT.n1100 0.1005
R6868 OUT.n1097 OUT.n1096 0.1005
R6869 OUT.n1093 OUT.n1092 0.1005
R6870 OUT.n1089 OUT.n1088 0.1005
R6871 OUT.n1085 OUT.n1084 0.1005
R6872 OUT.n1081 OUT.n1080 0.1005
R6873 OUT.n1077 OUT.n1076 0.1005
R6874 OUT.n1053 OUT.n1052 0.1005
R6875 OUT.n1301 OUT.n1300 0.1005
R6876 OUT.n1297 OUT.n1296 0.1005
R6877 OUT.n1293 OUT.n1292 0.1005
R6878 OUT.n1289 OUT.n1288 0.1005
R6879 OUT.n1285 OUT.n1284 0.1005
R6880 OUT.n1281 OUT.n1280 0.1005
R6881 OUT.n1277 OUT.n1276 0.1005
R6882 OUT.n1273 OUT.n1272 0.1005
R6883 OUT.n1269 OUT.n1268 0.1005
R6884 OUT.n1265 OUT.n1264 0.1005
R6885 OUT.n1261 OUT.n1260 0.1005
R6886 OUT.n1257 OUT.n1256 0.1005
R6887 OUT.n1253 OUT.n1252 0.1005
R6888 OUT.n1249 OUT.n1248 0.1005
R6889 OUT.n1245 OUT.n1244 0.1005
R6890 OUT.n1241 OUT.n1240 0.1005
R6891 OUT.n1237 OUT.n1236 0.1005
R6892 OUT.n1233 OUT.n1232 0.1005
R6893 OUT.n1229 OUT.n1228 0.1005
R6894 OUT.n1225 OUT.n1224 0.1005
R6895 OUT.n1221 OUT.n1220 0.1005
R6896 OUT.n1217 OUT.n1216 0.1005
R6897 OUT.n1213 OUT.n1212 0.1005
R6898 OUT.n1209 OUT.n1208 0.1005
R6899 OUT.n1205 OUT.n1204 0.1005
R6900 OUT.n1181 OUT.n1180 0.1005
R6901 OUT.n1431 OUT.n1430 0.1005
R6902 OUT.n1427 OUT.n1426 0.1005
R6903 OUT.n1423 OUT.n1422 0.1005
R6904 OUT.n1419 OUT.n1418 0.1005
R6905 OUT.n1415 OUT.n1414 0.1005
R6906 OUT.n1411 OUT.n1410 0.1005
R6907 OUT.n1407 OUT.n1406 0.1005
R6908 OUT.n1403 OUT.n1402 0.1005
R6909 OUT.n1399 OUT.n1398 0.1005
R6910 OUT.n1395 OUT.n1394 0.1005
R6911 OUT.n1391 OUT.n1390 0.1005
R6912 OUT.n1387 OUT.n1386 0.1005
R6913 OUT.n1383 OUT.n1382 0.1005
R6914 OUT.n1379 OUT.n1378 0.1005
R6915 OUT.n1375 OUT.n1374 0.1005
R6916 OUT.n1371 OUT.n1370 0.1005
R6917 OUT.n1367 OUT.n1366 0.1005
R6918 OUT.n1363 OUT.n1362 0.1005
R6919 OUT.n1359 OUT.n1358 0.1005
R6920 OUT.n1355 OUT.n1354 0.1005
R6921 OUT.n1351 OUT.n1350 0.1005
R6922 OUT.n1347 OUT.n1346 0.1005
R6923 OUT.n1343 OUT.n1342 0.1005
R6924 OUT.n1339 OUT.n1338 0.1005
R6925 OUT.n1335 OUT.n1334 0.1005
R6926 OUT.n1311 OUT.n1310 0.1005
R6927 OUT.n1559 OUT.n1558 0.1005
R6928 OUT.n1555 OUT.n1554 0.1005
R6929 OUT.n1551 OUT.n1550 0.1005
R6930 OUT.n1547 OUT.n1546 0.1005
R6931 OUT.n1543 OUT.n1542 0.1005
R6932 OUT.n1539 OUT.n1538 0.1005
R6933 OUT.n1535 OUT.n1534 0.1005
R6934 OUT.n1531 OUT.n1530 0.1005
R6935 OUT.n1527 OUT.n1526 0.1005
R6936 OUT.n1523 OUT.n1522 0.1005
R6937 OUT.n1519 OUT.n1518 0.1005
R6938 OUT.n1515 OUT.n1514 0.1005
R6939 OUT.n1511 OUT.n1510 0.1005
R6940 OUT.n1507 OUT.n1506 0.1005
R6941 OUT.n1503 OUT.n1502 0.1005
R6942 OUT.n1499 OUT.n1498 0.1005
R6943 OUT.n1495 OUT.n1494 0.1005
R6944 OUT.n1491 OUT.n1490 0.1005
R6945 OUT.n1487 OUT.n1486 0.1005
R6946 OUT.n1483 OUT.n1482 0.1005
R6947 OUT.n1479 OUT.n1478 0.1005
R6948 OUT.n1475 OUT.n1474 0.1005
R6949 OUT.n1471 OUT.n1470 0.1005
R6950 OUT.n1467 OUT.n1466 0.1005
R6951 OUT.n1463 OUT.n1462 0.1005
R6952 OUT.n1439 OUT.n1438 0.1005
R6953 OUT.n1687 OUT.n1686 0.1005
R6954 OUT.n1683 OUT.n1682 0.1005
R6955 OUT.n1679 OUT.n1678 0.1005
R6956 OUT.n1675 OUT.n1674 0.1005
R6957 OUT.n1671 OUT.n1670 0.1005
R6958 OUT.n1667 OUT.n1666 0.1005
R6959 OUT.n1663 OUT.n1662 0.1005
R6960 OUT.n1659 OUT.n1658 0.1005
R6961 OUT.n1655 OUT.n1654 0.1005
R6962 OUT.n1651 OUT.n1650 0.1005
R6963 OUT.n1647 OUT.n1646 0.1005
R6964 OUT.n1643 OUT.n1642 0.1005
R6965 OUT.n1639 OUT.n1638 0.1005
R6966 OUT.n1635 OUT.n1634 0.1005
R6967 OUT.n1631 OUT.n1630 0.1005
R6968 OUT.n1627 OUT.n1626 0.1005
R6969 OUT.n1623 OUT.n1622 0.1005
R6970 OUT.n1619 OUT.n1618 0.1005
R6971 OUT.n1615 OUT.n1614 0.1005
R6972 OUT.n1611 OUT.n1610 0.1005
R6973 OUT.n1607 OUT.n1606 0.1005
R6974 OUT.n1603 OUT.n1602 0.1005
R6975 OUT.n1599 OUT.n1598 0.1005
R6976 OUT.n1595 OUT.n1594 0.1005
R6977 OUT.n1591 OUT.n1590 0.1005
R6978 OUT.n1567 OUT.n1566 0.1005
R6979 OUT.n1817 OUT.n1816 0.1005
R6980 OUT.n1813 OUT.n1812 0.1005
R6981 OUT.n1809 OUT.n1808 0.1005
R6982 OUT.n1805 OUT.n1804 0.1005
R6983 OUT.n1801 OUT.n1800 0.1005
R6984 OUT.n1797 OUT.n1796 0.1005
R6985 OUT.n1793 OUT.n1792 0.1005
R6986 OUT.n1789 OUT.n1788 0.1005
R6987 OUT.n1785 OUT.n1784 0.1005
R6988 OUT.n1781 OUT.n1780 0.1005
R6989 OUT.n1777 OUT.n1776 0.1005
R6990 OUT.n1773 OUT.n1772 0.1005
R6991 OUT.n1769 OUT.n1768 0.1005
R6992 OUT.n1765 OUT.n1764 0.1005
R6993 OUT.n1761 OUT.n1760 0.1005
R6994 OUT.n1757 OUT.n1756 0.1005
R6995 OUT.n1753 OUT.n1752 0.1005
R6996 OUT.n1749 OUT.n1748 0.1005
R6997 OUT.n1745 OUT.n1744 0.1005
R6998 OUT.n1741 OUT.n1740 0.1005
R6999 OUT.n1737 OUT.n1736 0.1005
R7000 OUT.n1733 OUT.n1732 0.1005
R7001 OUT.n1729 OUT.n1728 0.1005
R7002 OUT.n1725 OUT.n1724 0.1005
R7003 OUT.n1721 OUT.n1720 0.1005
R7004 OUT.n1697 OUT.n1696 0.1005
R7005 OUT.n1946 OUT.n1945 0.1005
R7006 OUT.n1942 OUT.n1941 0.1005
R7007 OUT.n1938 OUT.n1937 0.1005
R7008 OUT.n1934 OUT.n1933 0.1005
R7009 OUT.n1930 OUT.n1929 0.1005
R7010 OUT.n1926 OUT.n1925 0.1005
R7011 OUT.n1922 OUT.n1921 0.1005
R7012 OUT.n1918 OUT.n1917 0.1005
R7013 OUT.n1914 OUT.n1913 0.1005
R7014 OUT.n1910 OUT.n1909 0.1005
R7015 OUT.n1906 OUT.n1905 0.1005
R7016 OUT.n1902 OUT.n1901 0.1005
R7017 OUT.n1898 OUT.n1897 0.1005
R7018 OUT.n1894 OUT.n1893 0.1005
R7019 OUT.n1890 OUT.n1889 0.1005
R7020 OUT.n1886 OUT.n1885 0.1005
R7021 OUT.n1882 OUT.n1881 0.1005
R7022 OUT.n1878 OUT.n1877 0.1005
R7023 OUT.n1874 OUT.n1873 0.1005
R7024 OUT.n1870 OUT.n1869 0.1005
R7025 OUT.n1866 OUT.n1865 0.1005
R7026 OUT.n1862 OUT.n1861 0.1005
R7027 OUT.n1858 OUT.n1857 0.1005
R7028 OUT.n1854 OUT.n1853 0.1005
R7029 OUT.n1850 OUT.n1849 0.1005
R7030 OUT.n1826 OUT.n1825 0.1005
R7031 OUT.n2074 OUT.n2073 0.1005
R7032 OUT.n2070 OUT.n2069 0.1005
R7033 OUT.n2066 OUT.n2065 0.1005
R7034 OUT.n2062 OUT.n2061 0.1005
R7035 OUT.n2058 OUT.n2057 0.1005
R7036 OUT.n2054 OUT.n2053 0.1005
R7037 OUT.n2050 OUT.n2049 0.1005
R7038 OUT.n2046 OUT.n2045 0.1005
R7039 OUT.n2042 OUT.n2041 0.1005
R7040 OUT.n2038 OUT.n2037 0.1005
R7041 OUT.n2034 OUT.n2033 0.1005
R7042 OUT.n2030 OUT.n2029 0.1005
R7043 OUT.n2026 OUT.n2025 0.1005
R7044 OUT.n2022 OUT.n2021 0.1005
R7045 OUT.n2018 OUT.n2017 0.1005
R7046 OUT.n2014 OUT.n2013 0.1005
R7047 OUT.n2010 OUT.n2009 0.1005
R7048 OUT.n2006 OUT.n2005 0.1005
R7049 OUT.n2002 OUT.n2001 0.1005
R7050 OUT.n1998 OUT.n1997 0.1005
R7051 OUT.n1994 OUT.n1993 0.1005
R7052 OUT.n1990 OUT.n1989 0.1005
R7053 OUT.n1986 OUT.n1985 0.1005
R7054 OUT.n1982 OUT.n1981 0.1005
R7055 OUT.n1978 OUT.n1977 0.1005
R7056 OUT.n1954 OUT.n1953 0.1005
R7057 OUT.n39 OUT.n38 0.0995099
R7058 OUT.n35 OUT.n34 0.0995099
R7059 OUT.n31 OUT.n30 0.0995099
R7060 OUT.n27 OUT.n26 0.0995099
R7061 OUT.n23 OUT.n22 0.0995099
R7062 OUT.n166 OUT.n165 0.0995099
R7063 OUT.n162 OUT.n161 0.0995099
R7064 OUT.n158 OUT.n157 0.0995099
R7065 OUT.n154 OUT.n153 0.0995099
R7066 OUT.n150 OUT.n149 0.0995099
R7067 OUT.n294 OUT.n293 0.0995099
R7068 OUT.n290 OUT.n289 0.0995099
R7069 OUT.n286 OUT.n285 0.0995099
R7070 OUT.n282 OUT.n281 0.0995099
R7071 OUT.n278 OUT.n277 0.0995099
R7072 OUT.n422 OUT.n421 0.0995099
R7073 OUT.n418 OUT.n417 0.0995099
R7074 OUT.n414 OUT.n413 0.0995099
R7075 OUT.n410 OUT.n409 0.0995099
R7076 OUT.n406 OUT.n405 0.0995099
R7077 OUT.n558 OUT.n557 0.0995099
R7078 OUT.n554 OUT.n553 0.0995099
R7079 OUT.n550 OUT.n549 0.0995099
R7080 OUT.n546 OUT.n545 0.0995099
R7081 OUT.n542 OUT.n541 0.0995099
R7082 OUT.n684 OUT.n683 0.0995099
R7083 OUT.n680 OUT.n679 0.0995099
R7084 OUT.n676 OUT.n675 0.0995099
R7085 OUT.n672 OUT.n671 0.0995099
R7086 OUT.n668 OUT.n667 0.0995099
R7087 OUT.n816 OUT.n815 0.0995099
R7088 OUT.n812 OUT.n811 0.0995099
R7089 OUT.n808 OUT.n807 0.0995099
R7090 OUT.n804 OUT.n803 0.0995099
R7091 OUT.n800 OUT.n799 0.0995099
R7092 OUT.n945 OUT.n944 0.0995099
R7093 OUT.n941 OUT.n940 0.0995099
R7094 OUT.n937 OUT.n936 0.0995099
R7095 OUT.n933 OUT.n932 0.0995099
R7096 OUT.n929 OUT.n928 0.0995099
R7097 OUT.n1073 OUT.n1072 0.0995099
R7098 OUT.n1069 OUT.n1068 0.0995099
R7099 OUT.n1065 OUT.n1064 0.0995099
R7100 OUT.n1061 OUT.n1060 0.0995099
R7101 OUT.n1057 OUT.n1056 0.0995099
R7102 OUT.n1201 OUT.n1200 0.0995099
R7103 OUT.n1197 OUT.n1196 0.0995099
R7104 OUT.n1193 OUT.n1192 0.0995099
R7105 OUT.n1189 OUT.n1188 0.0995099
R7106 OUT.n1185 OUT.n1184 0.0995099
R7107 OUT.n1331 OUT.n1330 0.0995099
R7108 OUT.n1327 OUT.n1326 0.0995099
R7109 OUT.n1323 OUT.n1322 0.0995099
R7110 OUT.n1319 OUT.n1318 0.0995099
R7111 OUT.n1315 OUT.n1314 0.0995099
R7112 OUT.n1459 OUT.n1458 0.0995099
R7113 OUT.n1455 OUT.n1454 0.0995099
R7114 OUT.n1451 OUT.n1450 0.0995099
R7115 OUT.n1447 OUT.n1446 0.0995099
R7116 OUT.n1443 OUT.n1442 0.0995099
R7117 OUT.n1587 OUT.n1586 0.0995099
R7118 OUT.n1583 OUT.n1582 0.0995099
R7119 OUT.n1579 OUT.n1578 0.0995099
R7120 OUT.n1575 OUT.n1574 0.0995099
R7121 OUT.n1571 OUT.n1570 0.0995099
R7122 OUT.n1717 OUT.n1716 0.0995099
R7123 OUT.n1713 OUT.n1712 0.0995099
R7124 OUT.n1709 OUT.n1708 0.0995099
R7125 OUT.n1705 OUT.n1704 0.0995099
R7126 OUT.n1701 OUT.n1700 0.0995099
R7127 OUT.n1846 OUT.n1845 0.0995099
R7128 OUT.n1842 OUT.n1841 0.0995099
R7129 OUT.n1838 OUT.n1837 0.0995099
R7130 OUT.n1834 OUT.n1833 0.0995099
R7131 OUT.n1830 OUT.n1829 0.0995099
R7132 OUT.n1974 OUT.n1973 0.0995099
R7133 OUT.n1970 OUT.n1969 0.0995099
R7134 OUT.n1966 OUT.n1965 0.0995099
R7135 OUT.n1962 OUT.n1961 0.0995099
R7136 OUT.n1958 OUT.n1957 0.0995099
R7137 OUT.n2177 OUT.n141 0.0948866
R7138 OUT.n2171 OUT.n268 0.0948866
R7139 OUT.n2164 OUT.n396 0.0948866
R7140 OUT.n525 OUT.n524 0.0948866
R7141 OUT.n661 OUT.n660 0.0948866
R7142 OUT.n787 OUT.n786 0.0948866
R7143 OUT.n919 OUT.n918 0.0948866
R7144 OUT.n2130 OUT.n1047 0.0948866
R7145 OUT.n2123 OUT.n1175 0.0948866
R7146 OUT.n1304 OUT.n1303 0.0948866
R7147 OUT.n2110 OUT.n1433 0.0948866
R7148 OUT.n2103 OUT.n1561 0.0948866
R7149 OUT.n1690 OUT.n1689 0.0948866
R7150 OUT.n1820 OUT.n1819 0.0948866
R7151 OUT.n2084 OUT.n1948 0.0948866
R7152 OUT.n2077 OUT.n2076 0.0948866
R7153 OUT.n0 OUT.t1032 0.078413
R7154 OUT.n3 OUT.t1027 0.078413
R7155 OUT.n2194 OUT 0.0598526
R7156 OUT.n2 OUT.n1 0.0554538
R7157 OUT.n1 OUT.n0 0.0554538
R7158 OUT.n5 OUT.n4 0.0554538
R7159 OUT.n4 OUT.n3 0.0554538
R7160 OUT.n20 OUT.n17 0.0505
R7161 OUT.n24 OUT.n21 0.0505
R7162 OUT.n28 OUT.n25 0.0505
R7163 OUT.n32 OUT.n29 0.0505
R7164 OUT.n36 OUT.n33 0.0505
R7165 OUT.n40 OUT.n37 0.0505
R7166 OUT.n44 OUT.n41 0.0505
R7167 OUT.n48 OUT.n45 0.0505
R7168 OUT.n52 OUT.n49 0.0505
R7169 OUT.n56 OUT.n53 0.0505
R7170 OUT.n60 OUT.n57 0.0505
R7171 OUT.n64 OUT.n61 0.0505
R7172 OUT.n68 OUT.n65 0.0505
R7173 OUT.n72 OUT.n69 0.0505
R7174 OUT.n76 OUT.n73 0.0505
R7175 OUT.n80 OUT.n77 0.0505
R7176 OUT.n84 OUT.n81 0.0505
R7177 OUT.n88 OUT.n85 0.0505
R7178 OUT.n92 OUT.n89 0.0505
R7179 OUT.n96 OUT.n93 0.0505
R7180 OUT.n100 OUT.n97 0.0505
R7181 OUT.n104 OUT.n101 0.0505
R7182 OUT.n108 OUT.n105 0.0505
R7183 OUT.n112 OUT.n109 0.0505
R7184 OUT.n116 OUT.n113 0.0505
R7185 OUT.n120 OUT.n117 0.0505
R7186 OUT.n124 OUT.n121 0.0505
R7187 OUT.n128 OUT.n125 0.0505
R7188 OUT.n132 OUT.n129 0.0505
R7189 OUT.n136 OUT.n133 0.0505
R7190 OUT.n140 OUT.n137 0.0505
R7191 OUT.n147 OUT.n144 0.0505
R7192 OUT.n151 OUT.n148 0.0505
R7193 OUT.n155 OUT.n152 0.0505
R7194 OUT.n159 OUT.n156 0.0505
R7195 OUT.n163 OUT.n160 0.0505
R7196 OUT.n167 OUT.n164 0.0505
R7197 OUT.n171 OUT.n168 0.0505
R7198 OUT.n175 OUT.n172 0.0505
R7199 OUT.n179 OUT.n176 0.0505
R7200 OUT.n183 OUT.n180 0.0505
R7201 OUT.n187 OUT.n184 0.0505
R7202 OUT.n191 OUT.n188 0.0505
R7203 OUT.n195 OUT.n192 0.0505
R7204 OUT.n199 OUT.n196 0.0505
R7205 OUT.n203 OUT.n200 0.0505
R7206 OUT.n207 OUT.n204 0.0505
R7207 OUT.n211 OUT.n208 0.0505
R7208 OUT.n215 OUT.n212 0.0505
R7209 OUT.n219 OUT.n216 0.0505
R7210 OUT.n223 OUT.n220 0.0505
R7211 OUT.n227 OUT.n224 0.0505
R7212 OUT.n231 OUT.n228 0.0505
R7213 OUT.n235 OUT.n232 0.0505
R7214 OUT.n239 OUT.n236 0.0505
R7215 OUT.n243 OUT.n240 0.0505
R7216 OUT.n247 OUT.n244 0.0505
R7217 OUT.n251 OUT.n248 0.0505
R7218 OUT.n255 OUT.n252 0.0505
R7219 OUT.n259 OUT.n256 0.0505
R7220 OUT.n263 OUT.n260 0.0505
R7221 OUT.n267 OUT.n264 0.0505
R7222 OUT.n275 OUT.n272 0.0505
R7223 OUT.n279 OUT.n276 0.0505
R7224 OUT.n283 OUT.n280 0.0505
R7225 OUT.n287 OUT.n284 0.0505
R7226 OUT.n291 OUT.n288 0.0505
R7227 OUT.n295 OUT.n292 0.0505
R7228 OUT.n299 OUT.n296 0.0505
R7229 OUT.n303 OUT.n300 0.0505
R7230 OUT.n307 OUT.n304 0.0505
R7231 OUT.n311 OUT.n308 0.0505
R7232 OUT.n315 OUT.n312 0.0505
R7233 OUT.n319 OUT.n316 0.0505
R7234 OUT.n323 OUT.n320 0.0505
R7235 OUT.n327 OUT.n324 0.0505
R7236 OUT.n331 OUT.n328 0.0505
R7237 OUT.n335 OUT.n332 0.0505
R7238 OUT.n339 OUT.n336 0.0505
R7239 OUT.n343 OUT.n340 0.0505
R7240 OUT.n347 OUT.n344 0.0505
R7241 OUT.n351 OUT.n348 0.0505
R7242 OUT.n355 OUT.n352 0.0505
R7243 OUT.n359 OUT.n356 0.0505
R7244 OUT.n363 OUT.n360 0.0505
R7245 OUT.n367 OUT.n364 0.0505
R7246 OUT.n371 OUT.n368 0.0505
R7247 OUT.n375 OUT.n372 0.0505
R7248 OUT.n379 OUT.n376 0.0505
R7249 OUT.n383 OUT.n380 0.0505
R7250 OUT.n387 OUT.n384 0.0505
R7251 OUT.n391 OUT.n388 0.0505
R7252 OUT.n395 OUT.n392 0.0505
R7253 OUT.n403 OUT.n400 0.0505
R7254 OUT.n407 OUT.n404 0.0505
R7255 OUT.n411 OUT.n408 0.0505
R7256 OUT.n415 OUT.n412 0.0505
R7257 OUT.n419 OUT.n416 0.0505
R7258 OUT.n423 OUT.n420 0.0505
R7259 OUT.n427 OUT.n424 0.0505
R7260 OUT.n431 OUT.n428 0.0505
R7261 OUT.n435 OUT.n432 0.0505
R7262 OUT.n439 OUT.n436 0.0505
R7263 OUT.n443 OUT.n440 0.0505
R7264 OUT.n447 OUT.n444 0.0505
R7265 OUT.n451 OUT.n448 0.0505
R7266 OUT.n455 OUT.n452 0.0505
R7267 OUT.n459 OUT.n456 0.0505
R7268 OUT.n463 OUT.n460 0.0505
R7269 OUT.n467 OUT.n464 0.0505
R7270 OUT.n471 OUT.n468 0.0505
R7271 OUT.n475 OUT.n472 0.0505
R7272 OUT.n479 OUT.n476 0.0505
R7273 OUT.n483 OUT.n480 0.0505
R7274 OUT.n487 OUT.n484 0.0505
R7275 OUT.n491 OUT.n488 0.0505
R7276 OUT.n495 OUT.n492 0.0505
R7277 OUT.n499 OUT.n496 0.0505
R7278 OUT.n503 OUT.n500 0.0505
R7279 OUT.n507 OUT.n504 0.0505
R7280 OUT.n511 OUT.n508 0.0505
R7281 OUT.n515 OUT.n512 0.0505
R7282 OUT.n519 OUT.n516 0.0505
R7283 OUT.n523 OUT.n520 0.0505
R7284 OUT.n539 OUT.n536 0.0505
R7285 OUT.n543 OUT.n540 0.0505
R7286 OUT.n547 OUT.n544 0.0505
R7287 OUT.n551 OUT.n548 0.0505
R7288 OUT.n555 OUT.n552 0.0505
R7289 OUT.n559 OUT.n556 0.0505
R7290 OUT.n563 OUT.n560 0.0505
R7291 OUT.n567 OUT.n564 0.0505
R7292 OUT.n571 OUT.n568 0.0505
R7293 OUT.n575 OUT.n572 0.0505
R7294 OUT.n579 OUT.n576 0.0505
R7295 OUT.n583 OUT.n580 0.0505
R7296 OUT.n587 OUT.n584 0.0505
R7297 OUT.n591 OUT.n588 0.0505
R7298 OUT.n595 OUT.n592 0.0505
R7299 OUT.n599 OUT.n596 0.0505
R7300 OUT.n603 OUT.n600 0.0505
R7301 OUT.n607 OUT.n604 0.0505
R7302 OUT.n611 OUT.n608 0.0505
R7303 OUT.n615 OUT.n612 0.0505
R7304 OUT.n619 OUT.n616 0.0505
R7305 OUT.n623 OUT.n620 0.0505
R7306 OUT.n627 OUT.n624 0.0505
R7307 OUT.n631 OUT.n628 0.0505
R7308 OUT.n635 OUT.n632 0.0505
R7309 OUT.n639 OUT.n636 0.0505
R7310 OUT.n643 OUT.n640 0.0505
R7311 OUT.n647 OUT.n644 0.0505
R7312 OUT.n651 OUT.n648 0.0505
R7313 OUT.n655 OUT.n652 0.0505
R7314 OUT.n659 OUT.n656 0.0505
R7315 OUT.n665 OUT.n662 0.0505
R7316 OUT.n669 OUT.n666 0.0505
R7317 OUT.n673 OUT.n670 0.0505
R7318 OUT.n677 OUT.n674 0.0505
R7319 OUT.n681 OUT.n678 0.0505
R7320 OUT.n685 OUT.n682 0.0505
R7321 OUT.n689 OUT.n686 0.0505
R7322 OUT.n693 OUT.n690 0.0505
R7323 OUT.n697 OUT.n694 0.0505
R7324 OUT.n701 OUT.n698 0.0505
R7325 OUT.n705 OUT.n702 0.0505
R7326 OUT.n709 OUT.n706 0.0505
R7327 OUT.n713 OUT.n710 0.0505
R7328 OUT.n717 OUT.n714 0.0505
R7329 OUT.n721 OUT.n718 0.0505
R7330 OUT.n725 OUT.n722 0.0505
R7331 OUT.n729 OUT.n726 0.0505
R7332 OUT.n733 OUT.n730 0.0505
R7333 OUT.n737 OUT.n734 0.0505
R7334 OUT.n741 OUT.n738 0.0505
R7335 OUT.n745 OUT.n742 0.0505
R7336 OUT.n749 OUT.n746 0.0505
R7337 OUT.n753 OUT.n750 0.0505
R7338 OUT.n757 OUT.n754 0.0505
R7339 OUT.n761 OUT.n758 0.0505
R7340 OUT.n765 OUT.n762 0.0505
R7341 OUT.n769 OUT.n766 0.0505
R7342 OUT.n773 OUT.n770 0.0505
R7343 OUT.n777 OUT.n774 0.0505
R7344 OUT.n781 OUT.n778 0.0505
R7345 OUT.n785 OUT.n782 0.0505
R7346 OUT.n797 OUT.n794 0.0505
R7347 OUT.n801 OUT.n798 0.0505
R7348 OUT.n805 OUT.n802 0.0505
R7349 OUT.n809 OUT.n806 0.0505
R7350 OUT.n813 OUT.n810 0.0505
R7351 OUT.n817 OUT.n814 0.0505
R7352 OUT.n821 OUT.n818 0.0505
R7353 OUT.n825 OUT.n822 0.0505
R7354 OUT.n829 OUT.n826 0.0505
R7355 OUT.n833 OUT.n830 0.0505
R7356 OUT.n837 OUT.n834 0.0505
R7357 OUT.n841 OUT.n838 0.0505
R7358 OUT.n845 OUT.n842 0.0505
R7359 OUT.n849 OUT.n846 0.0505
R7360 OUT.n853 OUT.n850 0.0505
R7361 OUT.n857 OUT.n854 0.0505
R7362 OUT.n861 OUT.n858 0.0505
R7363 OUT.n865 OUT.n862 0.0505
R7364 OUT.n869 OUT.n866 0.0505
R7365 OUT.n873 OUT.n870 0.0505
R7366 OUT.n877 OUT.n874 0.0505
R7367 OUT.n881 OUT.n878 0.0505
R7368 OUT.n885 OUT.n882 0.0505
R7369 OUT.n889 OUT.n886 0.0505
R7370 OUT.n893 OUT.n890 0.0505
R7371 OUT.n897 OUT.n894 0.0505
R7372 OUT.n901 OUT.n898 0.0505
R7373 OUT.n905 OUT.n902 0.0505
R7374 OUT.n909 OUT.n906 0.0505
R7375 OUT.n913 OUT.n910 0.0505
R7376 OUT.n917 OUT.n914 0.0505
R7377 OUT.n926 OUT.n923 0.0505
R7378 OUT.n930 OUT.n927 0.0505
R7379 OUT.n934 OUT.n931 0.0505
R7380 OUT.n938 OUT.n935 0.0505
R7381 OUT.n942 OUT.n939 0.0505
R7382 OUT.n946 OUT.n943 0.0505
R7383 OUT.n950 OUT.n947 0.0505
R7384 OUT.n954 OUT.n951 0.0505
R7385 OUT.n958 OUT.n955 0.0505
R7386 OUT.n962 OUT.n959 0.0505
R7387 OUT.n966 OUT.n963 0.0505
R7388 OUT.n970 OUT.n967 0.0505
R7389 OUT.n974 OUT.n971 0.0505
R7390 OUT.n978 OUT.n975 0.0505
R7391 OUT.n982 OUT.n979 0.0505
R7392 OUT.n986 OUT.n983 0.0505
R7393 OUT.n990 OUT.n987 0.0505
R7394 OUT.n994 OUT.n991 0.0505
R7395 OUT.n998 OUT.n995 0.0505
R7396 OUT.n1002 OUT.n999 0.0505
R7397 OUT.n1006 OUT.n1003 0.0505
R7398 OUT.n1010 OUT.n1007 0.0505
R7399 OUT.n1014 OUT.n1011 0.0505
R7400 OUT.n1018 OUT.n1015 0.0505
R7401 OUT.n1022 OUT.n1019 0.0505
R7402 OUT.n1026 OUT.n1023 0.0505
R7403 OUT.n1030 OUT.n1027 0.0505
R7404 OUT.n1034 OUT.n1031 0.0505
R7405 OUT.n1038 OUT.n1035 0.0505
R7406 OUT.n1042 OUT.n1039 0.0505
R7407 OUT.n1046 OUT.n1043 0.0505
R7408 OUT.n1054 OUT.n1051 0.0505
R7409 OUT.n1058 OUT.n1055 0.0505
R7410 OUT.n1062 OUT.n1059 0.0505
R7411 OUT.n1066 OUT.n1063 0.0505
R7412 OUT.n1070 OUT.n1067 0.0505
R7413 OUT.n1074 OUT.n1071 0.0505
R7414 OUT.n1078 OUT.n1075 0.0505
R7415 OUT.n1082 OUT.n1079 0.0505
R7416 OUT.n1086 OUT.n1083 0.0505
R7417 OUT.n1090 OUT.n1087 0.0505
R7418 OUT.n1094 OUT.n1091 0.0505
R7419 OUT.n1098 OUT.n1095 0.0505
R7420 OUT.n1102 OUT.n1099 0.0505
R7421 OUT.n1106 OUT.n1103 0.0505
R7422 OUT.n1110 OUT.n1107 0.0505
R7423 OUT.n1114 OUT.n1111 0.0505
R7424 OUT.n1118 OUT.n1115 0.0505
R7425 OUT.n1122 OUT.n1119 0.0505
R7426 OUT.n1126 OUT.n1123 0.0505
R7427 OUT.n1130 OUT.n1127 0.0505
R7428 OUT.n1134 OUT.n1131 0.0505
R7429 OUT.n1138 OUT.n1135 0.0505
R7430 OUT.n1142 OUT.n1139 0.0505
R7431 OUT.n1146 OUT.n1143 0.0505
R7432 OUT.n1150 OUT.n1147 0.0505
R7433 OUT.n1154 OUT.n1151 0.0505
R7434 OUT.n1158 OUT.n1155 0.0505
R7435 OUT.n1162 OUT.n1159 0.0505
R7436 OUT.n1166 OUT.n1163 0.0505
R7437 OUT.n1170 OUT.n1167 0.0505
R7438 OUT.n1174 OUT.n1171 0.0505
R7439 OUT.n1182 OUT.n1179 0.0505
R7440 OUT.n1186 OUT.n1183 0.0505
R7441 OUT.n1190 OUT.n1187 0.0505
R7442 OUT.n1194 OUT.n1191 0.0505
R7443 OUT.n1198 OUT.n1195 0.0505
R7444 OUT.n1202 OUT.n1199 0.0505
R7445 OUT.n1206 OUT.n1203 0.0505
R7446 OUT.n1210 OUT.n1207 0.0505
R7447 OUT.n1214 OUT.n1211 0.0505
R7448 OUT.n1218 OUT.n1215 0.0505
R7449 OUT.n1222 OUT.n1219 0.0505
R7450 OUT.n1226 OUT.n1223 0.0505
R7451 OUT.n1230 OUT.n1227 0.0505
R7452 OUT.n1234 OUT.n1231 0.0505
R7453 OUT.n1238 OUT.n1235 0.0505
R7454 OUT.n1242 OUT.n1239 0.0505
R7455 OUT.n1246 OUT.n1243 0.0505
R7456 OUT.n1250 OUT.n1247 0.0505
R7457 OUT.n1254 OUT.n1251 0.0505
R7458 OUT.n1258 OUT.n1255 0.0505
R7459 OUT.n1262 OUT.n1259 0.0505
R7460 OUT.n1266 OUT.n1263 0.0505
R7461 OUT.n1270 OUT.n1267 0.0505
R7462 OUT.n1274 OUT.n1271 0.0505
R7463 OUT.n1278 OUT.n1275 0.0505
R7464 OUT.n1282 OUT.n1279 0.0505
R7465 OUT.n1286 OUT.n1283 0.0505
R7466 OUT.n1290 OUT.n1287 0.0505
R7467 OUT.n1294 OUT.n1291 0.0505
R7468 OUT.n1298 OUT.n1295 0.0505
R7469 OUT.n1302 OUT.n1299 0.0505
R7470 OUT.n1312 OUT.n1309 0.0505
R7471 OUT.n1316 OUT.n1313 0.0505
R7472 OUT.n1320 OUT.n1317 0.0505
R7473 OUT.n1324 OUT.n1321 0.0505
R7474 OUT.n1328 OUT.n1325 0.0505
R7475 OUT.n1332 OUT.n1329 0.0505
R7476 OUT.n1336 OUT.n1333 0.0505
R7477 OUT.n1340 OUT.n1337 0.0505
R7478 OUT.n1344 OUT.n1341 0.0505
R7479 OUT.n1348 OUT.n1345 0.0505
R7480 OUT.n1352 OUT.n1349 0.0505
R7481 OUT.n1356 OUT.n1353 0.0505
R7482 OUT.n1360 OUT.n1357 0.0505
R7483 OUT.n1364 OUT.n1361 0.0505
R7484 OUT.n1368 OUT.n1365 0.0505
R7485 OUT.n1372 OUT.n1369 0.0505
R7486 OUT.n1376 OUT.n1373 0.0505
R7487 OUT.n1380 OUT.n1377 0.0505
R7488 OUT.n1384 OUT.n1381 0.0505
R7489 OUT.n1388 OUT.n1385 0.0505
R7490 OUT.n1392 OUT.n1389 0.0505
R7491 OUT.n1396 OUT.n1393 0.0505
R7492 OUT.n1400 OUT.n1397 0.0505
R7493 OUT.n1404 OUT.n1401 0.0505
R7494 OUT.n1408 OUT.n1405 0.0505
R7495 OUT.n1412 OUT.n1409 0.0505
R7496 OUT.n1416 OUT.n1413 0.0505
R7497 OUT.n1420 OUT.n1417 0.0505
R7498 OUT.n1424 OUT.n1421 0.0505
R7499 OUT.n1428 OUT.n1425 0.0505
R7500 OUT.n1432 OUT.n1429 0.0505
R7501 OUT.n1440 OUT.n1437 0.0505
R7502 OUT.n1444 OUT.n1441 0.0505
R7503 OUT.n1448 OUT.n1445 0.0505
R7504 OUT.n1452 OUT.n1449 0.0505
R7505 OUT.n1456 OUT.n1453 0.0505
R7506 OUT.n1460 OUT.n1457 0.0505
R7507 OUT.n1464 OUT.n1461 0.0505
R7508 OUT.n1468 OUT.n1465 0.0505
R7509 OUT.n1472 OUT.n1469 0.0505
R7510 OUT.n1476 OUT.n1473 0.0505
R7511 OUT.n1480 OUT.n1477 0.0505
R7512 OUT.n1484 OUT.n1481 0.0505
R7513 OUT.n1488 OUT.n1485 0.0505
R7514 OUT.n1492 OUT.n1489 0.0505
R7515 OUT.n1496 OUT.n1493 0.0505
R7516 OUT.n1500 OUT.n1497 0.0505
R7517 OUT.n1504 OUT.n1501 0.0505
R7518 OUT.n1508 OUT.n1505 0.0505
R7519 OUT.n1512 OUT.n1509 0.0505
R7520 OUT.n1516 OUT.n1513 0.0505
R7521 OUT.n1520 OUT.n1517 0.0505
R7522 OUT.n1524 OUT.n1521 0.0505
R7523 OUT.n1528 OUT.n1525 0.0505
R7524 OUT.n1532 OUT.n1529 0.0505
R7525 OUT.n1536 OUT.n1533 0.0505
R7526 OUT.n1540 OUT.n1537 0.0505
R7527 OUT.n1544 OUT.n1541 0.0505
R7528 OUT.n1548 OUT.n1545 0.0505
R7529 OUT.n1552 OUT.n1549 0.0505
R7530 OUT.n1556 OUT.n1553 0.0505
R7531 OUT.n1560 OUT.n1557 0.0505
R7532 OUT.n1568 OUT.n1565 0.0505
R7533 OUT.n1572 OUT.n1569 0.0505
R7534 OUT.n1576 OUT.n1573 0.0505
R7535 OUT.n1580 OUT.n1577 0.0505
R7536 OUT.n1584 OUT.n1581 0.0505
R7537 OUT.n1588 OUT.n1585 0.0505
R7538 OUT.n1592 OUT.n1589 0.0505
R7539 OUT.n1596 OUT.n1593 0.0505
R7540 OUT.n1600 OUT.n1597 0.0505
R7541 OUT.n1604 OUT.n1601 0.0505
R7542 OUT.n1608 OUT.n1605 0.0505
R7543 OUT.n1612 OUT.n1609 0.0505
R7544 OUT.n1616 OUT.n1613 0.0505
R7545 OUT.n1620 OUT.n1617 0.0505
R7546 OUT.n1624 OUT.n1621 0.0505
R7547 OUT.n1628 OUT.n1625 0.0505
R7548 OUT.n1632 OUT.n1629 0.0505
R7549 OUT.n1636 OUT.n1633 0.0505
R7550 OUT.n1640 OUT.n1637 0.0505
R7551 OUT.n1644 OUT.n1641 0.0505
R7552 OUT.n1648 OUT.n1645 0.0505
R7553 OUT.n1652 OUT.n1649 0.0505
R7554 OUT.n1656 OUT.n1653 0.0505
R7555 OUT.n1660 OUT.n1657 0.0505
R7556 OUT.n1664 OUT.n1661 0.0505
R7557 OUT.n1668 OUT.n1665 0.0505
R7558 OUT.n1672 OUT.n1669 0.0505
R7559 OUT.n1676 OUT.n1673 0.0505
R7560 OUT.n1680 OUT.n1677 0.0505
R7561 OUT.n1684 OUT.n1681 0.0505
R7562 OUT.n1688 OUT.n1685 0.0505
R7563 OUT.n1698 OUT.n1695 0.0505
R7564 OUT.n1702 OUT.n1699 0.0505
R7565 OUT.n1706 OUT.n1703 0.0505
R7566 OUT.n1710 OUT.n1707 0.0505
R7567 OUT.n1714 OUT.n1711 0.0505
R7568 OUT.n1718 OUT.n1715 0.0505
R7569 OUT.n1722 OUT.n1719 0.0505
R7570 OUT.n1726 OUT.n1723 0.0505
R7571 OUT.n1730 OUT.n1727 0.0505
R7572 OUT.n1734 OUT.n1731 0.0505
R7573 OUT.n1738 OUT.n1735 0.0505
R7574 OUT.n1742 OUT.n1739 0.0505
R7575 OUT.n1746 OUT.n1743 0.0505
R7576 OUT.n1750 OUT.n1747 0.0505
R7577 OUT.n1754 OUT.n1751 0.0505
R7578 OUT.n1758 OUT.n1755 0.0505
R7579 OUT.n1762 OUT.n1759 0.0505
R7580 OUT.n1766 OUT.n1763 0.0505
R7581 OUT.n1770 OUT.n1767 0.0505
R7582 OUT.n1774 OUT.n1771 0.0505
R7583 OUT.n1778 OUT.n1775 0.0505
R7584 OUT.n1782 OUT.n1779 0.0505
R7585 OUT.n1786 OUT.n1783 0.0505
R7586 OUT.n1790 OUT.n1787 0.0505
R7587 OUT.n1794 OUT.n1791 0.0505
R7588 OUT.n1798 OUT.n1795 0.0505
R7589 OUT.n1802 OUT.n1799 0.0505
R7590 OUT.n1806 OUT.n1803 0.0505
R7591 OUT.n1810 OUT.n1807 0.0505
R7592 OUT.n1814 OUT.n1811 0.0505
R7593 OUT.n1818 OUT.n1815 0.0505
R7594 OUT.n1827 OUT.n1824 0.0505
R7595 OUT.n1831 OUT.n1828 0.0505
R7596 OUT.n1835 OUT.n1832 0.0505
R7597 OUT.n1839 OUT.n1836 0.0505
R7598 OUT.n1843 OUT.n1840 0.0505
R7599 OUT.n1847 OUT.n1844 0.0505
R7600 OUT.n1851 OUT.n1848 0.0505
R7601 OUT.n1855 OUT.n1852 0.0505
R7602 OUT.n1859 OUT.n1856 0.0505
R7603 OUT.n1863 OUT.n1860 0.0505
R7604 OUT.n1867 OUT.n1864 0.0505
R7605 OUT.n1871 OUT.n1868 0.0505
R7606 OUT.n1875 OUT.n1872 0.0505
R7607 OUT.n1879 OUT.n1876 0.0505
R7608 OUT.n1883 OUT.n1880 0.0505
R7609 OUT.n1887 OUT.n1884 0.0505
R7610 OUT.n1891 OUT.n1888 0.0505
R7611 OUT.n1895 OUT.n1892 0.0505
R7612 OUT.n1899 OUT.n1896 0.0505
R7613 OUT.n1903 OUT.n1900 0.0505
R7614 OUT.n1907 OUT.n1904 0.0505
R7615 OUT.n1911 OUT.n1908 0.0505
R7616 OUT.n1915 OUT.n1912 0.0505
R7617 OUT.n1919 OUT.n1916 0.0505
R7618 OUT.n1923 OUT.n1920 0.0505
R7619 OUT.n1927 OUT.n1924 0.0505
R7620 OUT.n1931 OUT.n1928 0.0505
R7621 OUT.n1935 OUT.n1932 0.0505
R7622 OUT.n1939 OUT.n1936 0.0505
R7623 OUT.n1943 OUT.n1940 0.0505
R7624 OUT.n1947 OUT.n1944 0.0505
R7625 OUT.n1955 OUT.n1952 0.0505
R7626 OUT.n1959 OUT.n1956 0.0505
R7627 OUT.n1963 OUT.n1960 0.0505
R7628 OUT.n1967 OUT.n1964 0.0505
R7629 OUT.n1971 OUT.n1968 0.0505
R7630 OUT.n1975 OUT.n1972 0.0505
R7631 OUT.n1979 OUT.n1976 0.0505
R7632 OUT.n1983 OUT.n1980 0.0505
R7633 OUT.n1987 OUT.n1984 0.0505
R7634 OUT.n1991 OUT.n1988 0.0505
R7635 OUT.n1995 OUT.n1992 0.0505
R7636 OUT.n1999 OUT.n1996 0.0505
R7637 OUT.n2003 OUT.n2000 0.0505
R7638 OUT.n2007 OUT.n2004 0.0505
R7639 OUT.n2011 OUT.n2008 0.0505
R7640 OUT.n2015 OUT.n2012 0.0505
R7641 OUT.n2019 OUT.n2016 0.0505
R7642 OUT.n2023 OUT.n2020 0.0505
R7643 OUT.n2027 OUT.n2024 0.0505
R7644 OUT.n2031 OUT.n2028 0.0505
R7645 OUT.n2035 OUT.n2032 0.0505
R7646 OUT.n2039 OUT.n2036 0.0505
R7647 OUT.n2043 OUT.n2040 0.0505
R7648 OUT.n2047 OUT.n2044 0.0505
R7649 OUT.n2051 OUT.n2048 0.0505
R7650 OUT.n2055 OUT.n2052 0.0505
R7651 OUT.n2059 OUT.n2056 0.0505
R7652 OUT.n2063 OUT.n2060 0.0505
R7653 OUT.n2067 OUT.n2064 0.0505
R7654 OUT.n2071 OUT.n2068 0.0505
R7655 OUT.n2075 OUT.n2072 0.0505
R7656 OUT.n2 OUT.t1029 0.0234592
R7657 OUT.n1 OUT.t1026 0.0234592
R7658 OUT.n0 OUT.t1025 0.0234592
R7659 OUT.n5 OUT.t1031 0.0234592
R7660 OUT.n4 OUT.t1030 0.0234592
R7661 OUT.n3 OUT.t1028 0.0234592
R7662 OUT.n2079 OUT.n1951 0.0233125
R7663 OUT.n2134 OUT.n793 0.022375
R7664 OUT.n2119 OUT.n2118 0.022375
R7665 OUT.n2136 OUT.n2135 0.022375
R7666 OUT.n2086 OUT.n1823 0.0214375
R7667 OUT.n2175 OUT.n15 0.01925
R7668 OUT.n2173 OUT.n143 0.01925
R7669 OUT.n2168 OUT.n143 0.01925
R7670 OUT.n2166 OUT.n271 0.01925
R7671 OUT.n2160 OUT.n399 0.01925
R7672 OUT.n2155 OUT.n528 0.01925
R7673 OUT.n2150 OUT.n2149 0.01925
R7674 OUT.n2145 OUT.n2144 0.01925
R7675 OUT.n2140 OUT.n2139 0.01925
R7676 OUT.n2132 OUT.n922 0.01925
R7677 OUT.n2127 OUT.n922 0.01925
R7678 OUT.n2125 OUT.n1050 0.01925
R7679 OUT.n2114 OUT.n2113 0.01925
R7680 OUT.n2107 OUT.n1308 0.01925
R7681 OUT.n2105 OUT.n1436 0.01925
R7682 OUT.n2099 OUT.n2098 0.01925
R7683 OUT.n2094 OUT.n2093 0.01925
R7684 OUT.n2088 OUT.n1694 0.01925
R7685 OUT.n2088 OUT.n2087 0.01925
R7686 OUT.n2081 OUT.n1823 0.01925
R7687 OUT.n16 OUT.n11 0.01925
R7688 OUT.n2170 OUT.n2169 0.01925
R7689 OUT.n2159 OUT.n2158 0.01925
R7690 OUT.n2154 OUT.n2153 0.01925
R7691 OUT.n2141 OUT.n789 0.01925
R7692 OUT.n2129 OUT.n2128 0.01925
R7693 OUT.n2115 OUT.n1305 0.01925
R7694 OUT.n2109 OUT.n2108 0.01925
R7695 OUT.n2095 OUT.n1691 0.01925
R7696 OUT.n2090 OUT.n2089 0.01925
R7697 OUT.n2089 OUT.n1821 0.01925
R7698 OUT.n2083 OUT.n2082 0.01925
R7699 OUT.n2167 OUT.n2166 0.0183125
R7700 OUT.n2126 OUT.n2125 0.0183125
R7701 OUT.n2080 OUT.n2079 0.0183125
R7702 OUT.n2165 OUT.n269 0.0183125
R7703 OUT.n2124 OUT.n1048 0.0183125
R7704 OUT.n2078 OUT.n1949 0.0183125
R7705 OUT.n2172 OUT.n2171 0.0176875
R7706 OUT.n2148 OUT.n661 0.0176875
R7707 OUT.n2146 OUT.n787 0.0176875
R7708 OUT.n2123 OUT.n2122 0.0176875
R7709 OUT.n1304 OUT.n1176 0.0176875
R7710 OUT.n1690 OUT.n1562 0.0176875
R7711 OUT.n2184 OUT.n10 0.0173718
R7712 OUT.n531 OUT.n530 0.0173718
R7713 OUT.n2175 OUT.n2174 0.0170625
R7714 OUT.n2139 OUT.n2138 0.0170625
R7715 OUT.n2134 OUT.n2133 0.0170625
R7716 OUT.n2093 OUT.n2092 0.0170625
R7717 OUT.n2176 OUT.n142 0.0170625
R7718 OUT.n2135 OUT.n920 0.0170625
R7719 OUT.n529 OUT.n10 0.0161667
R7720 OUT.n530 OUT.n529 0.0161667
R7721 OUT.n2120 OUT.n2119 0.0151875
R7722 OUT.n2114 OUT.n1178 0.0151875
R7723 OUT.n2121 OUT.n1176 0.0151875
R7724 OUT.n2116 OUT.n2115 0.0151875
R7725 OUT.n2177 OUT.n2176 0.0145625
R7726 OUT.n2165 OUT.n2164 0.0145625
R7727 OUT.n2130 OUT.n2129 0.0145625
R7728 OUT.n2103 OUT.n2102 0.0145625
R7729 OUT.n1820 OUT.n1691 0.0145625
R7730 OUT.n2084 OUT.n2083 0.0145625
R7731 OUT.n2180 OUT.n14 0.0139375
R7732 OUT.n2144 OUT.n788 0.0139375
R7733 OUT.n2100 OUT.n1436 0.0139375
R7734 OUT.n2098 OUT.n1564 0.0139375
R7735 OUT.n2179 OUT.n16 0.0139375
R7736 OUT.n2143 OUT.n2142 0.0139375
R7737 OUT.n2102 OUT.n2101 0.0139375
R7738 OUT.n2097 OUT.n2096 0.0139375
R7739 OUT.n2161 OUT.n2160 0.013625
R7740 OUT.n2156 OUT.n2155 0.0120625
R7741 OUT.n2151 OUT.n2150 0.0120625
R7742 OUT.n2112 OUT.n1308 0.0120625
R7743 OUT.n2159 OUT.n397 0.0120625
R7744 OUT.n2152 OUT.n533 0.0120625
R7745 OUT.n14 OUT 0.0114375
R7746 OUT.n919 OUT.n789 0.0114375
R7747 OUT.n2110 OUT.n2109 0.0114375
R7748 OUT.n2190 OUT.n2187 0.0113462
R7749 OUT.n2151 OUT.n528 0.0108125
R7750 OUT.n2149 OUT.n535 0.0108125
R7751 OUT.n2107 OUT.n2106 0.0108125
R7752 OUT.n2153 OUT.n2152 0.0108125
R7753 OUT.n2148 OUT.n2147 0.0108125
R7754 OUT.n2108 OUT.n1434 0.0108125
R7755 OUT.n2183 OUT.n11 0.0100014
R7756 OUT.n2182 OUT.n12 0.0089375
R7757 OUT.n2145 OUT.n535 0.0089375
R7758 OUT.n2106 OUT.n2105 0.0089375
R7759 OUT.n2100 OUT.n2099 0.0089375
R7760 OUT.n2147 OUT.n2146 0.0089375
R7761 OUT.n2104 OUT.n1434 0.0089375
R7762 OUT.n2101 OUT.n1562 0.0089375
R7763 OUT OUT.n12 0.0083125
R7764 OUT.n2191 OUT.n2190 0.00821547
R7765 OUT.n2191 OUT.n2186 0.00821547
R7766 OUT.n2156 OUT.n399 0.0076875
R7767 OUT.n2113 OUT.n2112 0.0076875
R7768 OUT.n2158 OUT.n2157 0.0076875
R7769 OUT.n2111 OUT.n1305 0.0076875
R7770 OUT.n2085 OUT.n2084 0.007375
R7771 OUT.n2189 OUT.n8 0.00641447
R7772 OUT.n2185 OUT.n6 0.00641447
R7773 OUT.n2192 OUT.n9 0.00641447
R7774 OUT.n2193 OUT.n7 0.00641447
R7775 OUT.n2189 OUT.n2188 0.00641447
R7776 OUT.n2186 OUT.n7 0.00641447
R7777 OUT.n2185 OUT.n8 0.00641447
R7778 OUT.n9 OUT.n6 0.00641447
R7779 OUT.n2163 OUT.n2162 0.006125
R7780 OUT.n532 OUT.n525 0.006125
R7781 OUT.n2137 OUT.n919 0.006125
R7782 OUT.n2180 OUT.n15 0.0058125
R7783 OUT.n2140 OUT.n788 0.0058125
R7784 OUT.n2094 OUT.n1564 0.0058125
R7785 OUT.n2179 OUT.n2178 0.0058125
R7786 OUT.n2154 OUT.n532 0.0058125
R7787 OUT.n2142 OUT.n2141 0.0058125
R7788 OUT.n2096 OUT.n2095 0.0058125
R7789 OUT.n2178 OUT.n2177 0.0051875
R7790 OUT.n2164 OUT.n2163 0.0051875
R7791 OUT.n2131 OUT.n2130 0.0051875
R7792 OUT.n2117 OUT.n1304 0.0051875
R7793 OUT.n2104 OUT.n2103 0.0051875
R7794 OUT.n398 OUT.n271 0.0045625
R7795 OUT.n2120 OUT.n1050 0.0045625
R7796 OUT.n2118 OUT.n1178 0.0045625
R7797 OUT.n2122 OUT.n2121 0.0045625
R7798 OUT.n2117 OUT.n2116 0.0045625
R7799 OUT.n2091 OUT.n1820 0.003
R7800 OUT.n2174 OUT.n2173 0.0026875
R7801 OUT.n2138 OUT.n793 0.0026875
R7802 OUT.n2133 OUT.n2132 0.0026875
R7803 OUT.n2092 OUT.n1694 0.0026875
R7804 OUT.n2172 OUT.n142 0.0026875
R7805 OUT.n2137 OUT.n2136 0.0026875
R7806 OUT.n2131 OUT.n920 0.0026875
R7807 OUT.n2091 OUT.n2090 0.0026875
R7808 OUT.n2161 OUT.n398 0.0020625
R7809 OUT.n2171 OUT.n2170 0.0020625
R7810 OUT.n2162 OUT.n397 0.0020625
R7811 OUT.n661 OUT.n533 0.0020625
R7812 OUT.n2143 OUT.n787 0.0020625
R7813 OUT.n2124 OUT.n2123 0.0020625
R7814 OUT.n2097 OUT.n1690 0.0020625
R7815 OUT.n2078 OUT.n2077 0.0020625
R7816 OUT.n2168 OUT.n2167 0.0014375
R7817 OUT.n2127 OUT.n2126 0.0014375
R7818 OUT.n2087 OUT.n2086 0.0014375
R7819 OUT.n2081 OUT.n2080 0.0014375
R7820 OUT.n2169 OUT.n269 0.0014375
R7821 OUT.n2128 OUT.n1048 0.0014375
R7822 OUT.n2085 OUT.n1821 0.0014375
R7823 OUT.n2082 OUT.n1949 0.0014375
R7824 OUT.n2157 OUT.n525 0.001125
R7825 OUT.n2111 OUT.n2110 0.001125
R7826 bias-network_0.IBIAS1.n0 bias-network_0.IBIAS1.t28 473.726
R7827 bias-network_0.IBIAS1.n2 bias-network_0.IBIAS1.t30 473.051
R7828 bias-network_0.IBIAS1.n1 bias-network_0.IBIAS1.t33 473.051
R7829 bias-network_0.IBIAS1.n0 bias-network_0.IBIAS1.t34 473.051
R7830 bias-network_0.IBIAS1.n12 bias-network_0.IBIAS1.t4 253.282
R7831 bias-network_0.IBIAS1.n11 bias-network_0.IBIAS1.t29 253.282
R7832 bias-network_0.IBIAS1.n10 bias-network_0.IBIAS1.t35 253.282
R7833 bias-network_0.IBIAS1.n9 bias-network_0.IBIAS1.t2 253.282
R7834 bias-network_0.IBIAS1.n18 bias-network_0.IBIAS1.t0 253.282
R7835 bias-network_0.IBIAS1.n17 bias-network_0.IBIAS1.t32 253.282
R7836 bias-network_0.IBIAS1.n16 bias-network_0.IBIAS1.t31 253.282
R7837 bias-network_0.IBIAS1.n15 bias-network_0.IBIAS1.t6 253.282
R7838 bias-network_0.IBIAS1.n9 bias-network_0.IBIAS1.t3 215.909
R7839 bias-network_0.IBIAS1.n19 bias-network_0.IBIAS1.t1 215.798
R7840 bias-network_0.IBIAS1.n14 bias-network_0.IBIAS1.n13 198.368
R7841 bias-network_0.IBIAS1.n21 bias-network_0.IBIAS1.t26 120.68
R7842 bias-network_0.IBIAS1.n26 bias-network_0.IBIAS1.t23 120.68
R7843 bias-network_0.IBIAS1.n21 bias-network_0.IBIAS1.t27 120.487
R7844 bias-network_0.IBIAS1.n26 bias-network_0.IBIAS1.t24 120.487
R7845 bias-network_0.IBIAS1.n24 bias-network_0.IBIAS1.n22 97.4808
R7846 bias-network_0.IBIAS1.n24 bias-network_0.IBIAS1.n23 97.2868
R7847 bias-network_0.IBIAS1.n32 bias-network_0.IBIAS1.n31 67.4008
R7848 bias-network_0.IBIAS1.n35 bias-network_0.IBIAS1.n34 67.4008
R7849 bias-network_0.IBIAS1.n32 bias-network_0.IBIAS1.n30 31.1036
R7850 bias-network_0.IBIAS1.n35 bias-network_0.IBIAS1.n33 31.1036
R7851 bias-network_0.IBIAS1.n23 bias-network_0.IBIAS1.t19 23.2005
R7852 bias-network_0.IBIAS1.n23 bias-network_0.IBIAS1.t21 23.2005
R7853 bias-network_0.IBIAS1.n22 bias-network_0.IBIAS1.t18 23.2005
R7854 bias-network_0.IBIAS1.n22 bias-network_0.IBIAS1.t20 23.2005
R7855 bias-network_0.IBIAS1.n13 bias-network_0.IBIAS1.t5 17.3126
R7856 bias-network_0.IBIAS1.n13 bias-network_0.IBIAS1.t7 17.3126
R7857 bias-network_0.IBIAS1.n31 bias-network_0.IBIAS1.t15 16.5719
R7858 bias-network_0.IBIAS1.n31 bias-network_0.IBIAS1.t12 16.5719
R7859 bias-network_0.IBIAS1.n34 bias-network_0.IBIAS1.t13 16.5719
R7860 bias-network_0.IBIAS1.n34 bias-network_0.IBIAS1.t14 16.5719
R7861 bias-network_0.IBIAS1.n29 bias-network_0.IBIAS1 9.22639
R7862 bias-network_0.IBIAS1.n7 bias-network_0.IBIAS1.n6 5.29018
R7863 bias-network_0.IBIAS1.n29 bias-network_0.IBIAS1.n20 5.16389
R7864 bias-network_0.IBIAS1 bias-network_0.IBIAS1.n8 4.563
R7865 bias-network_0.IBIAS1.n37 bias-network_0.IBIAS1.n36 4.5005
R7866 bias-network_0.IBIAS1.n30 bias-network_0.IBIAS1.t17 4.08121
R7867 bias-network_0.IBIAS1.n30 bias-network_0.IBIAS1.t22 4.08121
R7868 bias-network_0.IBIAS1.n33 bias-network_0.IBIAS1.t25 4.08121
R7869 bias-network_0.IBIAS1.n33 bias-network_0.IBIAS1.t16 4.08121
R7870 bias-network_0.IBIAS1.n20 bias-network_0.IBIAS1 2.3135
R7871 bias-network_0.IBIAS1.n3 bias-network_0.IBIAS1 2.3135
R7872 bias-network_0.IBIAS1.n8 bias-network_0.IBIAS1.n7 2.26703
R7873 bias-network_0.IBIAS1.n25 bias-network_0.IBIAS1.n21 2.21747
R7874 bias-network_0.IBIAS1.n20 bias-network_0.IBIAS1.n19 2.10291
R7875 bias-network_0.IBIAS1.n27 bias-network_0.IBIAS1.n25 1.46479
R7876 bias-network_0.IBIAS1.n36 bias-network_0.IBIAS1.n35 0.988
R7877 bias-network_0.IBIAS1.n4 bias-network_0.IBIAS1.t8 0.855479
R7878 bias-network_0.IBIAS1.n3 bias-network_0.IBIAS1.n2 0.81975
R7879 bias-network_0.IBIAS1.n25 bias-network_0.IBIAS1.n24 0.753184
R7880 bias-network_0.IBIAS1.n27 bias-network_0.IBIAS1.n26 0.753184
R7881 bias-network_0.IBIAS1.n35 bias-network_0.IBIAS1.n32 0.7505
R7882 bias-network_0.IBIAS1.n2 bias-network_0.IBIAS1.n1 0.663
R7883 bias-network_0.IBIAS1.n5 bias-network_0.IBIAS1.n4 0.595833
R7884 bias-network_0.IBIAS1.n6 bias-network_0.IBIAS1.n5 0.595833
R7885 bias-network_0.IBIAS1.n28 bias-network_0.IBIAS1.n27 0.532071
R7886 bias-network_0.IBIAS1.n7 bias-network_0.IBIAS1.n3 0.503328
R7887 bias-network_0.IBIAS1.n6 bias-network_0.IBIAS1.t11 0.260146
R7888 bias-network_0.IBIAS1.n5 bias-network_0.IBIAS1.t10 0.260146
R7889 bias-network_0.IBIAS1.n4 bias-network_0.IBIAS1.t9 0.260146
R7890 bias-network_0.IBIAS1.n1 bias-network_0.IBIAS1.n0 0.2255
R7891 bias-network_0.IBIAS1.n16 bias-network_0.IBIAS1.n15 0.223
R7892 bias-network_0.IBIAS1.n17 bias-network_0.IBIAS1.n16 0.223
R7893 bias-network_0.IBIAS1.n18 bias-network_0.IBIAS1.n17 0.223
R7894 bias-network_0.IBIAS1.n10 bias-network_0.IBIAS1.n9 0.223
R7895 bias-network_0.IBIAS1.n11 bias-network_0.IBIAS1.n10 0.223
R7896 bias-network_0.IBIAS1.n12 bias-network_0.IBIAS1.n11 0.223
R7897 bias-network_0.IBIAS1.n28 bias-network_0.IBIAS1 0.135115
R7898 bias-network_0.IBIAS1.n36 bias-network_0.IBIAS1.n8 0.1255
R7899 bias-network_0.IBIAS1.n19 bias-network_0.IBIAS1.n18 0.108
R7900 bias-network_0.IBIAS1 bias-network_0.IBIAS1.n37 0.063
R7901 bias-network_0.IBIAS1.n14 bias-network_0.IBIAS1.n12 0.048
R7902 bias-network_0.IBIAS1.n37 bias-network_0.IBIAS1.n29 0.038
R7903 bias-network_0.IBIAS1.n15 bias-network_0.IBIAS1.n14 0.038
R7904 bias-network_0.IBIAS1 bias-network_0.IBIAS1.n28 0.03175
R7905 a_3816_4748.n65 a_3816_4748.n64 202.269
R7906 a_3816_4748.n64 a_3816_4748.n63 202.266
R7907 a_3816_4748.n36 a_3816_4748.n35 29.74
R7908 a_3816_4748.n51 a_3816_4748.n50 29.74
R7909 a_3816_4748.n5 a_3816_4748.n4 29.74
R7910 a_3816_4748.n20 a_3816_4748.n19 29.74
R7911 a_3816_4748.n63 a_3816_4748.t2 17.3126
R7912 a_3816_4748.n63 a_3816_4748.t1 17.3126
R7913 a_3816_4748.n65 a_3816_4748.t0 17.3126
R7914 a_3816_4748.t3 a_3816_4748.n65 17.3126
R7915 a_3816_4748.n43 a_3816_4748.n42 4.5005
R7916 a_3816_4748.n34 a_3816_4748.n33 4.5005
R7917 a_3816_4748.n38 a_3816_4748.n37 4.5005
R7918 a_3816_4748.n58 a_3816_4748.n57 4.5005
R7919 a_3816_4748.n49 a_3816_4748.n48 4.5005
R7920 a_3816_4748.n53 a_3816_4748.n52 4.5005
R7921 a_3816_4748.n12 a_3816_4748.n11 4.5005
R7922 a_3816_4748.n3 a_3816_4748.n2 4.5005
R7923 a_3816_4748.n7 a_3816_4748.n6 4.5005
R7924 a_3816_4748.n27 a_3816_4748.n26 4.5005
R7925 a_3816_4748.n18 a_3816_4748.n17 4.5005
R7926 a_3816_4748.n22 a_3816_4748.n21 4.5005
R7927 a_3816_4748.n35 a_3816_4748.t11 4.08121
R7928 a_3816_4748.n35 a_3816_4748.t6 4.08121
R7929 a_3816_4748.n50 a_3816_4748.t5 4.08121
R7930 a_3816_4748.n50 a_3816_4748.t10 4.08121
R7931 a_3816_4748.n4 a_3816_4748.t7 4.08121
R7932 a_3816_4748.n4 a_3816_4748.t8 4.08121
R7933 a_3816_4748.n19 a_3816_4748.t9 4.08121
R7934 a_3816_4748.n19 a_3816_4748.t4 4.08121
R7935 a_3816_4748.n45 a_3816_4748.n44 3.47871
R7936 a_3816_4748.n60 a_3816_4748.n59 3.47871
R7937 a_3816_4748.n14 a_3816_4748.n13 3.47871
R7938 a_3816_4748.n29 a_3816_4748.n28 3.47871
R7939 a_3816_4748.n40 a_3816_4748.n34 3.4105
R7940 a_3816_4748.n42 a_3816_4748.n41 3.4105
R7941 a_3816_4748.n32 a_3816_4748.n31 3.4105
R7942 a_3816_4748.n55 a_3816_4748.n49 3.4105
R7943 a_3816_4748.n57 a_3816_4748.n56 3.4105
R7944 a_3816_4748.n47 a_3816_4748.n46 3.4105
R7945 a_3816_4748.n9 a_3816_4748.n3 3.4105
R7946 a_3816_4748.n11 a_3816_4748.n10 3.4105
R7947 a_3816_4748.n1 a_3816_4748.n0 3.4105
R7948 a_3816_4748.n24 a_3816_4748.n18 3.4105
R7949 a_3816_4748.n26 a_3816_4748.n25 3.4105
R7950 a_3816_4748.n16 a_3816_4748.n15 3.4105
R7951 a_3816_4748.n44 a_3816_4748.n43 2.38642
R7952 a_3816_4748.n59 a_3816_4748.n58 2.38642
R7953 a_3816_4748.n13 a_3816_4748.n12 2.38642
R7954 a_3816_4748.n28 a_3816_4748.n27 2.38642
R7955 a_3816_4748.n39 a_3816_4748.n36 1.34877
R7956 a_3816_4748.n54 a_3816_4748.n51 1.34877
R7957 a_3816_4748.n8 a_3816_4748.n5 1.34877
R7958 a_3816_4748.n23 a_3816_4748.n20 1.34877
R7959 a_3816_4748.n40 a_3816_4748.n39 0.756722
R7960 a_3816_4748.n55 a_3816_4748.n54 0.756722
R7961 a_3816_4748.n9 a_3816_4748.n8 0.756722
R7962 a_3816_4748.n24 a_3816_4748.n23 0.756722
R7963 a_3816_4748.n64 a_3816_4748.n62 0.244045
R7964 a_3816_4748.n61 a_3816_4748.n45 0.206837
R7965 a_3816_4748.n30 a_3816_4748.n14 0.206837
R7966 a_3816_4748.n39 a_3816_4748.n38 0.177197
R7967 a_3816_4748.n54 a_3816_4748.n53 0.177197
R7968 a_3816_4748.n8 a_3816_4748.n7 0.177197
R7969 a_3816_4748.n23 a_3816_4748.n22 0.177197
R7970 a_3816_4748.n43 a_3816_4748.n33 0.135917
R7971 a_3816_4748.n37 a_3816_4748.n33 0.135917
R7972 a_3816_4748.n42 a_3816_4748.n32 0.135917
R7973 a_3816_4748.n42 a_3816_4748.n34 0.135917
R7974 a_3816_4748.n38 a_3816_4748.n34 0.135917
R7975 a_3816_4748.n58 a_3816_4748.n48 0.135917
R7976 a_3816_4748.n52 a_3816_4748.n48 0.135917
R7977 a_3816_4748.n57 a_3816_4748.n47 0.135917
R7978 a_3816_4748.n57 a_3816_4748.n49 0.135917
R7979 a_3816_4748.n53 a_3816_4748.n49 0.135917
R7980 a_3816_4748.n12 a_3816_4748.n2 0.135917
R7981 a_3816_4748.n6 a_3816_4748.n2 0.135917
R7982 a_3816_4748.n11 a_3816_4748.n1 0.135917
R7983 a_3816_4748.n11 a_3816_4748.n3 0.135917
R7984 a_3816_4748.n7 a_3816_4748.n3 0.135917
R7985 a_3816_4748.n27 a_3816_4748.n17 0.135917
R7986 a_3816_4748.n21 a_3816_4748.n17 0.135917
R7987 a_3816_4748.n26 a_3816_4748.n16 0.135917
R7988 a_3816_4748.n26 a_3816_4748.n18 0.135917
R7989 a_3816_4748.n22 a_3816_4748.n18 0.135917
R7990 a_3816_4748.n61 a_3816_4748.n60 0.104292
R7991 a_3816_4748.n30 a_3816_4748.n29 0.104292
R7992 a_3816_4748.n37 a_3816_4748.n36 0.0755
R7993 a_3816_4748.n52 a_3816_4748.n51 0.0755
R7994 a_3816_4748.n6 a_3816_4748.n5 0.0755
R7995 a_3816_4748.n21 a_3816_4748.n20 0.0755
R7996 a_3816_4748.n44 a_3816_4748.n32 0.0667303
R7997 a_3816_4748.n59 a_3816_4748.n47 0.0667303
R7998 a_3816_4748.n13 a_3816_4748.n1 0.0667303
R7999 a_3816_4748.n28 a_3816_4748.n16 0.0667303
R8000 a_3816_4748.n62 a_3816_4748.n30 0.0539091
R8001 a_3816_4748.n45 a_3816_4748.n31 0.0514167
R8002 a_3816_4748.n41 a_3816_4748.n31 0.0514167
R8003 a_3816_4748.n41 a_3816_4748.n40 0.0514167
R8004 a_3816_4748.n60 a_3816_4748.n46 0.0514167
R8005 a_3816_4748.n56 a_3816_4748.n46 0.0514167
R8006 a_3816_4748.n56 a_3816_4748.n55 0.0514167
R8007 a_3816_4748.n14 a_3816_4748.n0 0.0514167
R8008 a_3816_4748.n10 a_3816_4748.n0 0.0514167
R8009 a_3816_4748.n10 a_3816_4748.n9 0.0514167
R8010 a_3816_4748.n29 a_3816_4748.n15 0.0514167
R8011 a_3816_4748.n25 a_3816_4748.n15 0.0514167
R8012 a_3816_4748.n25 a_3816_4748.n24 0.0514167
R8013 a_3816_4748.n62 a_3816_4748.n61 0.0496364
R8014 a_3638_4130.n49 a_3638_4130.t4 203.476
R8015 a_3638_4130.n50 a_3638_4130.t15 203.476
R8016 a_3638_4130.n51 a_3638_4130.t14 203.476
R8017 a_3638_4130.n52 a_3638_4130.t10 203.476
R8018 a_3638_4130.n47 a_3638_4130.t8 203.476
R8019 a_3638_4130.n46 a_3638_4130.t13 203.476
R8020 a_3638_4130.n45 a_3638_4130.t12 203.476
R8021 a_3638_4130.n44 a_3638_4130.t6 203.476
R8022 a_3638_4130.n43 a_3638_4130.t7 81.3798
R8023 a_3638_4130.n48 a_3638_4130.t5 81.3797
R8024 a_3638_4130.n42 a_3638_4130.n41 64.7672
R8025 a_3638_4130.n11 a_3638_4130.t2 33.8207
R8026 a_3638_4130.t3 a_3638_4130.n70 33.8207
R8027 a_3638_4130.n29 a_3638_4130.n28 29.74
R8028 a_3638_4130.n41 a_3638_4130.t9 16.5719
R8029 a_3638_4130.n41 a_3638_4130.t11 16.5719
R8030 a_3638_4130.n56 a_3638_4130.n42 4.59425
R8031 a_3638_4130.n19 a_3638_4130.n18 4.5005
R8032 a_3638_4130.n8 a_3638_4130.n7 4.5005
R8033 a_3638_4130.n14 a_3638_4130.n13 4.5005
R8034 a_3638_4130.n12 a_3638_4130.n10 4.5005
R8035 a_3638_4130.n37 a_3638_4130.n36 4.5005
R8036 a_3638_4130.n25 a_3638_4130.n24 4.5005
R8037 a_3638_4130.n32 a_3638_4130.n31 4.5005
R8038 a_3638_4130.n30 a_3638_4130.n27 4.5005
R8039 a_3638_4130.n55 a_3638_4130.n54 4.5005
R8040 a_3638_4130.n69 a_3638_4130.n68 4.5005
R8041 a_3638_4130.n67 a_3638_4130.n1 4.5005
R8042 a_3638_4130.n66 a_3638_4130.n65 4.5005
R8043 a_3638_4130.n64 a_3638_4130.n4 4.5005
R8044 a_3638_4130.n43 a_3638_4130.n40 4.2667
R8045 a_3638_4130.n48 a_3638_4130.n40 4.26246
R8046 a_3638_4130.n28 a_3638_4130.t0 4.08121
R8047 a_3638_4130.n28 a_3638_4130.t1 4.08121
R8048 a_3638_4130.n21 a_3638_4130.n20 3.47871
R8049 a_3638_4130.n39 a_3638_4130.n38 3.47871
R8050 a_3638_4130.n63 a_3638_4130.n59 3.47869
R8051 a_3638_4130.n55 a_3638_4130.n40 3.4152
R8052 a_3638_4130.n6 a_3638_4130.n5 3.4105
R8053 a_3638_4130.n18 a_3638_4130.n17 3.4105
R8054 a_3638_4130.n16 a_3638_4130.n8 3.4105
R8055 a_3638_4130.n15 a_3638_4130.n14 3.4105
R8056 a_3638_4130.n57 a_3638_4130.n56 3.4105
R8057 a_3638_4130.n23 a_3638_4130.n22 3.4105
R8058 a_3638_4130.n36 a_3638_4130.n35 3.4105
R8059 a_3638_4130.n34 a_3638_4130.n25 3.4105
R8060 a_3638_4130.n33 a_3638_4130.n32 3.4105
R8061 a_3638_4130.n62 a_3638_4130.n61 3.4105
R8062 a_3638_4130.n60 a_3638_4130.n4 3.4105
R8063 a_3638_4130.n66 a_3638_4130.n3 3.4105
R8064 a_3638_4130.n67 a_3638_4130.n2 3.4105
R8065 a_3638_4130.n20 a_3638_4130.n19 2.38642
R8066 a_3638_4130.n38 a_3638_4130.n37 2.38642
R8067 a_3638_4130.n64 a_3638_4130.n63 2.38366
R8068 a_3638_4130.n11 a_3638_4130.n9 1.22589
R8069 a_3638_4130.n29 a_3638_4130.n26 1.22589
R8070 a_3638_4130.n70 a_3638_4130.n0 1.22127
R8071 a_3638_4130.n2 a_3638_4130.n0 0.660297
R8072 a_3638_4130.n15 a_3638_4130.n9 0.660172
R8073 a_3638_4130.n33 a_3638_4130.n26 0.660172
R8074 a_3638_4130.n45 a_3638_4130.n44 0.384121
R8075 a_3638_4130.n46 a_3638_4130.n45 0.384121
R8076 a_3638_4130.n47 a_3638_4130.n46 0.384121
R8077 a_3638_4130.n52 a_3638_4130.n51 0.384121
R8078 a_3638_4130.n51 a_3638_4130.n50 0.384121
R8079 a_3638_4130.n50 a_3638_4130.n49 0.384121
R8080 a_3638_4130.n58 a_3638_4130.n21 0.27164
R8081 a_3638_4130.n59 a_3638_4130.n58 0.27164
R8082 a_3638_4130.n44 a_3638_4130.n43 0.24901
R8083 a_3638_4130.n49 a_3638_4130.n48 0.244753
R8084 a_3638_4130.n58 a_3638_4130.n57 0.219442
R8085 a_3638_4130.n68 a_3638_4130.n0 0.203997
R8086 a_3638_4130.n10 a_3638_4130.n9 0.203925
R8087 a_3638_4130.n27 a_3638_4130.n26 0.203925
R8088 a_3638_4130.n56 a_3638_4130.n55 0.1755
R8089 a_3638_4130.n13 a_3638_4130.n12 0.135917
R8090 a_3638_4130.n13 a_3638_4130.n7 0.135917
R8091 a_3638_4130.n19 a_3638_4130.n7 0.135917
R8092 a_3638_4130.n14 a_3638_4130.n10 0.135917
R8093 a_3638_4130.n14 a_3638_4130.n8 0.135917
R8094 a_3638_4130.n18 a_3638_4130.n8 0.135917
R8095 a_3638_4130.n18 a_3638_4130.n6 0.135917
R8096 a_3638_4130.n31 a_3638_4130.n30 0.135917
R8097 a_3638_4130.n31 a_3638_4130.n24 0.135917
R8098 a_3638_4130.n37 a_3638_4130.n24 0.135917
R8099 a_3638_4130.n32 a_3638_4130.n27 0.135917
R8100 a_3638_4130.n32 a_3638_4130.n25 0.135917
R8101 a_3638_4130.n36 a_3638_4130.n25 0.135917
R8102 a_3638_4130.n36 a_3638_4130.n23 0.135917
R8103 a_3638_4130.n68 a_3638_4130.n67 0.135917
R8104 a_3638_4130.n67 a_3638_4130.n66 0.135917
R8105 a_3638_4130.n66 a_3638_4130.n4 0.135917
R8106 a_3638_4130.n62 a_3638_4130.n4 0.135917
R8107 a_3638_4130.n69 a_3638_4130.n1 0.133697
R8108 a_3638_4130.n65 a_3638_4130.n1 0.133697
R8109 a_3638_4130.n65 a_3638_4130.n64 0.133697
R8110 a_3638_4130.n54 a_3638_4130.n53 0.12675
R8111 a_3638_4130.n53 a_3638_4130.n52 0.0867069
R8112 a_3638_4130.n53 a_3638_4130.n47 0.0823966
R8113 a_3638_4130.n54 a_3638_4130.n42 0.08175
R8114 a_3638_4130.n63 a_3638_4130.n62 0.0667461
R8115 a_3638_4130.n20 a_3638_4130.n6 0.0667303
R8116 a_3638_4130.n38 a_3638_4130.n23 0.0667303
R8117 a_3638_4130.n16 a_3638_4130.n15 0.0514167
R8118 a_3638_4130.n17 a_3638_4130.n16 0.0514167
R8119 a_3638_4130.n17 a_3638_4130.n5 0.0514167
R8120 a_3638_4130.n21 a_3638_4130.n5 0.0514167
R8121 a_3638_4130.n34 a_3638_4130.n33 0.0514167
R8122 a_3638_4130.n35 a_3638_4130.n34 0.0514167
R8123 a_3638_4130.n35 a_3638_4130.n22 0.0514167
R8124 a_3638_4130.n39 a_3638_4130.n22 0.0514167
R8125 a_3638_4130.n3 a_3638_4130.n2 0.0514167
R8126 a_3638_4130.n60 a_3638_4130.n3 0.0514167
R8127 a_3638_4130.n61 a_3638_4130.n60 0.0514167
R8128 a_3638_4130.n61 a_3638_4130.n59 0.0514167
R8129 a_3638_4130.n57 a_3638_4130.n40 0.0099
R8130 a_3638_4130.n12 a_3638_4130.n11 0.00883333
R8131 a_3638_4130.n30 a_3638_4130.n29 0.00883333
R8132 a_3638_4130.n70 a_3638_4130.n69 0.00869672
R8133 a_3638_4130.n58 a_3638_4130.n39 0.00245833
R8134 bias-network_0.VREF.n0 bias-network_0.VREF.t27 473.053
R8135 bias-network_0.VREF.n3 bias-network_0.VREF.t23 473.053
R8136 bias-network_0.VREF.n2 bias-network_0.VREF.t24 472.827
R8137 bias-network_0.VREF.n1 bias-network_0.VREF.t18 472.827
R8138 bias-network_0.VREF.n0 bias-network_0.VREF.t17 472.827
R8139 bias-network_0.VREF.n5 bias-network_0.VREF.t40 472.827
R8140 bias-network_0.VREF.n4 bias-network_0.VREF.t39 472.827
R8141 bias-network_0.VREF.n3 bias-network_0.VREF.t33 472.827
R8142 bias-network_0.VREF.n18 bias-network_0.VREF.t9 120.35
R8143 bias-network_0.VREF.n9 bias-network_0.VREF.t11 120.35
R8144 bias-network_0.VREF.n33 bias-network_0.VREF.t5 120.35
R8145 bias-network_0.VREF.n36 bias-network_0.VREF.t7 120.35
R8146 bias-network_0.VREF.n52 bias-network_0.VREF.n51 97.1505
R8147 bias-network_0.VREF.n28 bias-network_0.VREF.n27 97.1505
R8148 bias-network_0.VREF.n65 bias-network_0.VREF.t36 26.8475
R8149 bias-network_0.VREF.n64 bias-network_0.VREF.t38 26.8475
R8150 bias-network_0.VREF.n63 bias-network_0.VREF.t28 26.8475
R8151 bias-network_0.VREF.n62 bias-network_0.VREF.t29 26.8475
R8152 bias-network_0.VREF.n10 bias-network_0.VREF.t10 26.8475
R8153 bias-network_0.VREF.n22 bias-network_0.VREF.t8 26.8475
R8154 bias-network_0.VREF.n56 bias-network_0.VREF.t30 26.8475
R8155 bias-network_0.VREF.n57 bias-network_0.VREF.t31 26.8475
R8156 bias-network_0.VREF.n58 bias-network_0.VREF.t19 26.8475
R8157 bias-network_0.VREF.n59 bias-network_0.VREF.t20 26.8475
R8158 bias-network_0.VREF.n55 bias-network_0.VREF.t2 26.8475
R8159 bias-network_0.VREF.n24 bias-network_0.VREF.t0 26.8475
R8160 bias-network_0.VREF.n42 bias-network_0.VREF.t35 26.8475
R8161 bias-network_0.VREF.n41 bias-network_0.VREF.t37 26.8475
R8162 bias-network_0.VREF.n40 bias-network_0.VREF.t25 26.8475
R8163 bias-network_0.VREF.n39 bias-network_0.VREF.t26 26.8475
R8164 bias-network_0.VREF.n37 bias-network_0.VREF.t6 26.8475
R8165 bias-network_0.VREF.n17 bias-network_0.VREF.t4 26.8475
R8166 bias-network_0.VREF.n44 bias-network_0.VREF.t32 26.8475
R8167 bias-network_0.VREF.n45 bias-network_0.VREF.t34 26.8475
R8168 bias-network_0.VREF.n46 bias-network_0.VREF.t21 26.8475
R8169 bias-network_0.VREF.n47 bias-network_0.VREF.t22 26.8475
R8170 bias-network_0.VREF.n49 bias-network_0.VREF.t14 26.8475
R8171 bias-network_0.VREF.n30 bias-network_0.VREF.t12 26.8475
R8172 bias-network_0.VREF.n51 bias-network_0.VREF.t3 23.2005
R8173 bias-network_0.VREF.n51 bias-network_0.VREF.t15 23.2005
R8174 bias-network_0.VREF.n27 bias-network_0.VREF.t1 23.2005
R8175 bias-network_0.VREF.n27 bias-network_0.VREF.t13 23.2005
R8176 bias-network_0.VREF.n67 bias-network_0.VREF.t16 22.5047
R8177 bias-network_0.VREF.n7 bias-network_0.VREF.n6 7.54202
R8178 bias-network_0.VREF.n6 bias-network_0.VREF 5.33623
R8179 bias-network_0.VREF bias-network_0.VREF.n2 3.35775
R8180 bias-network_0.VREF bias-network_0.VREF.n5 3.35775
R8181 bias-network_0.VREF bias-network_0.VREF.n67 3.25058
R8182 bias-network_0.VREF.n6 bias-network_0.VREF 2.71751
R8183 bias-network_0.VREF.n1 bias-network_0.VREF.n0 0.663
R8184 bias-network_0.VREF.n4 bias-network_0.VREF.n3 0.663
R8185 bias-network_0.VREF.n21 bias-network_0.VREF.n13 0.6255
R8186 bias-network_0.VREF.n54 bias-network_0.VREF.n12 0.6255
R8187 bias-network_0.VREF.n16 bias-network_0.VREF.n15 0.6255
R8188 bias-network_0.VREF.n50 bias-network_0.VREF.n14 0.6255
R8189 bias-network_0.VREF.n25 bias-network_0.VREF.n23 0.556056
R8190 bias-network_0.VREF.n61 bias-network_0.VREF.n60 0.556056
R8191 bias-network_0.VREF.n48 bias-network_0.VREF.n38 0.556013
R8192 bias-network_0.VREF.n32 bias-network_0.VREF.n31 0.556013
R8193 bias-network_0.VREF.n33 bias-network_0.VREF.n32 0.513671
R8194 bias-network_0.VREF.n38 bias-network_0.VREF.n36 0.513671
R8195 bias-network_0.VREF.n61 bias-network_0.VREF.n9 0.499782
R8196 bias-network_0.VREF.n23 bias-network_0.VREF.n18 0.499782
R8197 bias-network_0.VREF.n43 bias-network_0.VREF.n42 0.424827
R8198 bias-network_0.VREF.n67 bias-network_0.VREF.n66 0.366066
R8199 bias-network_0.VREF.n64 bias-network_0.VREF.n63 0.30357
R8200 bias-network_0.VREF.n58 bias-network_0.VREF.n57 0.30357
R8201 bias-network_0.VREF.n41 bias-network_0.VREF.n40 0.30357
R8202 bias-network_0.VREF.n46 bias-network_0.VREF.n45 0.30357
R8203 bias-network_0.VREF.n66 bias-network_0.VREF.n8 0.283519
R8204 bias-network_0.VREF.n52 bias-network_0.VREF.n11 0.28175
R8205 bias-network_0.VREF.n29 bias-network_0.VREF.n28 0.28175
R8206 bias-network_0.VREF.n20 bias-network_0.VREF.n18 0.280672
R8207 bias-network_0.VREF.n19 bias-network_0.VREF.n9 0.280672
R8208 bias-network_0.VREF.n34 bias-network_0.VREF.n33 0.280672
R8209 bias-network_0.VREF.n36 bias-network_0.VREF.n35 0.280672
R8210 bias-network_0.VREF.n43 bias-network_0.VREF.n8 0.271726
R8211 bias-network_0.VREF.n53 bias-network_0.VREF.n52 0.271333
R8212 bias-network_0.VREF.n28 bias-network_0.VREF.n26 0.271333
R8213 bias-network_0.VREF.n34 bias-network_0.VREF.n16 0.2505
R8214 bias-network_0.VREF.n35 bias-network_0.VREF.n14 0.2505
R8215 bias-network_0.VREF.n19 bias-network_0.VREF.n12 0.234875
R8216 bias-network_0.VREF.n21 bias-network_0.VREF.n20 0.234875
R8217 bias-network_0.VREF.n20 bias-network_0.VREF.n19 0.233259
R8218 bias-network_0.VREF.n35 bias-network_0.VREF.n34 0.233259
R8219 bias-network_0.VREF.n26 bias-network_0.VREF.n13 0.229667
R8220 bias-network_0.VREF.n54 bias-network_0.VREF.n53 0.229667
R8221 bias-network_0.VREF.n2 bias-network_0.VREF.n1 0.2255
R8222 bias-network_0.VREF.n5 bias-network_0.VREF.n4 0.2255
R8223 bias-network_0.VREF.n62 bias-network_0.VREF.n61 0.216808
R8224 bias-network_0.VREF.n60 bias-network_0.VREF.n59 0.216808
R8225 bias-network_0.VREF.n39 bias-network_0.VREF.n38 0.216808
R8226 bias-network_0.VREF.n48 bias-network_0.VREF.n47 0.216808
R8227 bias-network_0.VREF.n26 bias-network_0.VREF.n15 0.214042
R8228 bias-network_0.VREF.n53 bias-network_0.VREF.n50 0.214042
R8229 bias-network_0.VREF.n63 bias-network_0.VREF.n62 0.210388
R8230 bias-network_0.VREF.n65 bias-network_0.VREF.n64 0.210388
R8231 bias-network_0.VREF.n59 bias-network_0.VREF.n58 0.210388
R8232 bias-network_0.VREF.n57 bias-network_0.VREF.n56 0.210388
R8233 bias-network_0.VREF.n40 bias-network_0.VREF.n39 0.210388
R8234 bias-network_0.VREF.n42 bias-network_0.VREF.n41 0.210388
R8235 bias-network_0.VREF.n47 bias-network_0.VREF.n46 0.210388
R8236 bias-network_0.VREF.n45 bias-network_0.VREF.n44 0.210388
R8237 bias-network_0.VREF.n60 bias-network_0.VREF.n11 0.204204
R8238 bias-network_0.VREF.n29 bias-network_0.VREF.n25 0.204204
R8239 bias-network_0.VREF.n31 bias-network_0.VREF.n29 0.190883
R8240 bias-network_0.VREF.n48 bias-network_0.VREF.n11 0.190315
R8241 bias-network_0.VREF.n66 bias-network_0.VREF.n65 0.141808
R8242 bias-network_0.VREF.n56 bias-network_0.VREF.n8 0.141808
R8243 bias-network_0.VREF.n44 bias-network_0.VREF.n43 0.141808
R8244 bias-network_0.VREF bias-network_0.VREF.n7 0.0973943
R8245 bias-network_0.VREF.n23 bias-network_0.VREF.n22 0.0776032
R8246 bias-network_0.VREF.n61 bias-network_0.VREF.n10 0.0776032
R8247 bias-network_0.VREF.n25 bias-network_0.VREF.n24 0.0776032
R8248 bias-network_0.VREF.n60 bias-network_0.VREF.n55 0.0776032
R8249 bias-network_0.VREF.n32 bias-network_0.VREF.n17 0.0776032
R8250 bias-network_0.VREF.n38 bias-network_0.VREF.n37 0.0776032
R8251 bias-network_0.VREF.n49 bias-network_0.VREF.n48 0.0776032
R8252 bias-network_0.VREF.n31 bias-network_0.VREF.n30 0.077035
R8253 bias-network_0.VREF.n50 bias-network_0.VREF.n49 0.0747623
R8254 bias-network_0.VREF.n55 bias-network_0.VREF.n54 0.0747623
R8255 bias-network_0.VREF.n12 bias-network_0.VREF.n10 0.0747623
R8256 bias-network_0.VREF.n22 bias-network_0.VREF.n21 0.0747623
R8257 bias-network_0.VREF.n24 bias-network_0.VREF.n13 0.0747623
R8258 bias-network_0.VREF.n37 bias-network_0.VREF.n14 0.0747623
R8259 bias-network_0.VREF.n17 bias-network_0.VREF.n16 0.0747623
R8260 bias-network_0.VREF.n30 bias-network_0.VREF.n15 0.0747623
R8261 bias-network_0.VREF.n21 bias-network_0.VREF.n12 0.0618636
R8262 bias-network_0.VREF.n54 bias-network_0.VREF.n13 0.0618636
R8263 bias-network_0.VREF.n16 bias-network_0.VREF.n14 0.0618636
R8264 bias-network_0.VREF.n50 bias-network_0.VREF.n15 0.0618636
R8265 bias-network_0.VREF.n7 bias-network_0.VREF 0.0272857
R8266 VSS.n170 VSS.n169 99761.3
R8267 VSS.n132 VSS.n26 25784
R8268 VSS.n170 VSS.n26 25784
R8269 VSS.n110 VSS.n96 10266.7
R8270 VSS.n111 VSS.n26 10096.6
R8271 VSS.n94 VSS.n27 7495.85
R8272 VSS.n94 VSS.n28 7495.85
R8273 VSS.n168 VSS.n28 7476.15
R8274 VSS.n168 VSS.n27 7476.15
R8275 VSS.n187 VSS.n14 7289
R8276 VSS.n187 VSS.n15 7289
R8277 VSS.n189 VSS.n15 7289
R8278 VSS.n189 VSS.n14 7289
R8279 VSS.n130 VSS.n41 6025.88
R8280 VSS.n113 VSS.n41 6025.88
R8281 VSS.n130 VSS.n42 6025.88
R8282 VSS.n113 VSS.n42 6025.88
R8283 VSS.n108 VSS.n23 6025.88
R8284 VSS.n173 VSS.n23 6025.88
R8285 VSS.n173 VSS.n24 6025.88
R8286 VSS.n108 VSS.n24 6025.88
R8287 VSS.n171 VSS.n170 5207.3
R8288 VSS.n134 VSS.n40 4826.5
R8289 VSS.n134 VSS.n36 4826.5
R8290 VSS.n92 VSS.n36 4826.5
R8291 VSS.n92 VSS.n40 4826.5
R8292 VSS.t51 VSS.n171 305.13
R8293 VSS.t43 VSS.t29 263.421
R8294 VSS.t46 VSS.t21 263.421
R8295 VSS.n133 VSS.t38 251.843
R8296 VSS.n167 VSS.n29 251.115
R8297 VSS.n63 VSS.t17 224.632
R8298 VSS.n167 VSS.n166 204.8
R8299 VSS.n131 VSS.t2 194.174
R8300 VSS.t59 VSS.t16 191.304
R8301 VSS.t16 VSS.t85 191.304
R8302 VSS.t66 VSS.t50 191.304
R8303 VSS.t50 VSS.t63 191.304
R8304 VSS.t86 VSS.t68 191.304
R8305 VSS.t68 VSS.t64 191.304
R8306 VSS.t64 VSS.t51 191.304
R8307 VSS.n169 VSS.t81 184.685
R8308 VSS.t74 VSS.t0 178.87
R8309 VSS.t70 VSS.t105 178.87
R8310 VSS.n114 VSS.n58 177.319
R8311 VSS.n129 VSS.n44 177.319
R8312 VSS.n107 VSS.n103 177.319
R8313 VSS.n174 VSS.n22 177.319
R8314 VSS.n112 VSS.t59 176
R8315 VSS.n172 VSS.t86 176
R8316 VSS.n176 VSS.n6 175.018
R8317 VSS.t14 VSS.t2 170.262
R8318 VSS.t10 VSS.t14 170.262
R8319 VSS.t6 VSS.t10 170.262
R8320 VSS.t98 VSS.n95 162.685
R8321 VSS.t49 VSS.t101 159.739
R8322 VSS.t60 VSS.t4 157.827
R8323 VSS.t87 VSS.t109 157.827
R8324 VSS.t94 VSS.t81 150.526
R8325 VSS.n114 VSS.n113 146.25
R8326 VSS.n113 VSS.n112 146.25
R8327 VSS.n130 VSS.n129 146.25
R8328 VSS.n131 VSS.n130 146.25
R8329 VSS.n108 VSS.n107 146.25
R8330 VSS.n109 VSS.n108 146.25
R8331 VSS.n174 VSS.n173 146.25
R8332 VSS.n173 VSS.n172 146.25
R8333 VSS.t19 VSS.n62 145.316
R8334 VSS.t89 VSS.t98 138.947
R8335 VSS.t95 VSS.t8 136.784
R8336 VSS.t72 VSS.t115 136.784
R8337 VSS.t63 VSS.n110 133.913
R8338 VSS.t8 VSS.n60 132
R8339 VSS.t69 VSS.t61 127.368
R8340 VSS.t55 VSS.t58 127.368
R8341 VSS.n74 VSS.n73 126.105
R8342 VSS.n83 VSS.n82 126.105
R8343 VSS.n76 VSS.n75 122.075
R8344 VSS.n85 VSS.n84 122.075
R8345 VSS.n62 VSS.t26 118.106
R8346 VSS.t113 VSS.t76 117.653
R8347 VSS.t67 VSS.t94 115.79
R8348 VSS.t91 VSS.t67 115.79
R8349 VSS.t79 VSS.t91 115.79
R8350 VSS.t56 VSS.t79 115.79
R8351 VSS.t93 VSS.t56 115.79
R8352 VSS.t80 VSS.t93 115.79
R8353 VSS.t57 VSS.t80 115.79
R8354 VSS.t75 VSS.t57 115.79
R8355 VSS.t71 VSS.t75 115.79
R8356 VSS.t54 VSS.t77 115.79
R8357 VSS.t84 VSS.t78 115.79
R8358 VSS.t78 VSS.t55 115.79
R8359 VSS.t62 VSS.t89 115.79
R8360 VSS.n95 VSS.n63 115.79
R8361 VSS.t88 VSS.t107 115.74
R8362 VSS.n188 VSS.t92 113.826
R8363 VSS.n96 VSS.t54 111.159
R8364 VSS.n58 VSS.n57 107.671
R8365 VSS.n55 VSS.n44 107.671
R8366 VSS.n103 VSS.n102 107.671
R8367 VSS.n100 VSS.n22 107.671
R8368 VSS.n111 VSS.t66 105.218
R8369 VSS.t77 VSS.t69 104.212
R8370 VSS.t58 VSS.t62 104.212
R8371 VSS.n58 VSS.n52 98.2386
R8372 VSS.n57 VSS.n53 98.2386
R8373 VSS.n55 VSS.n54 98.2386
R8374 VSS.n44 VSS.n43 98.2386
R8375 VSS.n103 VSS.n97 98.2386
R8376 VSS.n102 VSS.n98 98.2386
R8377 VSS.n100 VSS.n99 98.2386
R8378 VSS.n22 VSS.n21 98.2386
R8379 VSS.t103 VSS.t90 96.6092
R8380 VSS.n72 VSS.n71 92.5005
R8381 VSS.n73 VSS.n70 92.5005
R8382 VSS.n74 VSS.n69 92.5005
R8383 VSS.n75 VSS.n68 92.5005
R8384 VSS.n76 VSS.n67 92.5005
R8385 VSS.n77 VSS.n66 92.5005
R8386 VSS.n38 VSS.n37 92.5005
R8387 VSS.n82 VSS.n81 92.5005
R8388 VSS.n83 VSS.n80 92.5005
R8389 VSS.n84 VSS.n79 92.5005
R8390 VSS.n85 VSS.n78 92.5005
R8391 VSS.n87 VSS.n86 92.5005
R8392 VSS.n77 VSS.n76 87.2301
R8393 VSS.n75 VSS.n74 87.2301
R8394 VSS.n73 VSS.n72 87.2301
R8395 VSS.n87 VSS.n85 87.2301
R8396 VSS.n84 VSS.n83 87.2301
R8397 VSS.n82 VSS.n38 87.2301
R8398 VSS.t85 VSS.n111 86.0875
R8399 VSS.n59 VSS.t6 85.1309
R8400 VSS.t12 VSS.n59 85.1309
R8401 VSS.n25 VSS.t103 85.1309
R8402 VSS.t61 VSS.n61 77.5794
R8403 VSS.n115 VSS.n114 76.8005
R8404 VSS.n129 VSS.n128 76.8005
R8405 VSS.n107 VSS.n106 76.8005
R8406 VSS.n175 VSS.n174 76.8005
R8407 VSS.t107 VSS.t73 75.5657
R8408 VSS.t90 VSS.t113 73.6527
R8409 VSS.n65 VSS.t99 66.8025
R8410 VSS.n29 VSS.t82 66.8025
R8411 VSS.n90 VSS.n77 66.3709
R8412 VSS.n88 VSS.n87 66.3709
R8413 VSS.n166 VSS.n165 66.243
R8414 VSS.n72 VSS.n34 63.7635
R8415 VSS.n149 VSS.n38 63.7635
R8416 VSS.n176 VSS.t52 58.2692
R8417 VSS.n51 VSS.t96 58.2692
R8418 VSS.n93 VSS.n91 57.6005
R8419 VSS.n93 VSS.n33 57.6005
R8420 VSS.n15 VSS.n6 55.0412
R8421 VSS.t115 VSS.t88 54.5222
R8422 VSS.n56 VSS.n55 53.8358
R8423 VSS.n57 VSS.n56 53.8358
R8424 VSS.n102 VSS.n101 53.8358
R8425 VSS.n101 VSS.n100 53.8358
R8426 VSS.t76 VSS.t111 52.6092
R8427 VSS.n132 VSS.n131 50.6962
R8428 VSS.n166 VSS.t83 44.729
R8429 VSS.n157 VSS.t100 40.0914
R8430 VSS.n142 VSS.t97 39.3493
R8431 VSS.n200 VSS.t53 39.3493
R8432 VSS.n60 VSS.t12 38.2614
R8433 VSS.n61 VSS.t71 38.211
R8434 VSS.n109 VSS.t49 34.4353
R8435 VSS.t4 VSS.t95 33.4788
R8436 VSS.t109 VSS.t72 33.4788
R8437 VSS.t101 VSS.t92 31.5657
R8438 VSS.n121 VSS.n42 26.5914
R8439 VSS.n59 VSS.n42 26.5914
R8440 VSS.n56 VSS.n41 26.5914
R8441 VSS.n59 VSS.n41 26.5914
R8442 VSS.n101 VSS.n23 26.5914
R8443 VSS.n25 VSS.n23 26.5914
R8444 VSS.n24 VSS.n20 26.5914
R8445 VSS.n25 VSS.n24 26.5914
R8446 VSS.n188 VSS.t111 24.8701
R8447 VSS.n133 VSS.n132 24.3163
R8448 VSS.n65 VSS.n64 23.6229
R8449 VSS.n66 VSS.t44 23.2005
R8450 VSS.n66 VSS.t20 23.2005
R8451 VSS.n67 VSS.t45 23.2005
R8452 VSS.n67 VSS.t25 23.2005
R8453 VSS.n68 VSS.t32 23.2005
R8454 VSS.n68 VSS.t41 23.2005
R8455 VSS.n69 VSS.t33 23.2005
R8456 VSS.n69 VSS.t42 23.2005
R8457 VSS.n70 VSS.t18 23.2005
R8458 VSS.n70 VSS.t30 23.2005
R8459 VSS.n71 VSS.t23 23.2005
R8460 VSS.n71 VSS.t31 23.2005
R8461 VSS.n86 VSS.t47 23.2005
R8462 VSS.n86 VSS.t39 23.2005
R8463 VSS.n78 VSS.t48 23.2005
R8464 VSS.n78 VSS.t40 23.2005
R8465 VSS.n79 VSS.t36 23.2005
R8466 VSS.n79 VSS.t34 23.2005
R8467 VSS.n80 VSS.t37 23.2005
R8468 VSS.n80 VSS.t35 23.2005
R8469 VSS.n81 VSS.t27 23.2005
R8470 VSS.n81 VSS.t22 23.2005
R8471 VSS.n37 VSS.t28 23.2005
R8472 VSS.n37 VSS.t24 23.2005
R8473 VSS.n64 VSS.n29 23.1013
R8474 VSS.n110 VSS.n109 22.957
R8475 VSS.n202 VSS.t65 22.0527
R8476 VSS.n89 VSS.n40 19.5005
R8477 VSS.n62 VSS.n40 19.5005
R8478 VSS.n150 VSS.n36 19.5005
R8479 VSS.n62 VSS.n36 19.5005
R8480 VSS.n105 VSS.n50 17.3516
R8481 VSS.n52 VSS.t5 16.5719
R8482 VSS.n52 VSS.t1 16.5719
R8483 VSS.n53 VSS.t13 16.5719
R8484 VSS.n53 VSS.t9 16.5719
R8485 VSS.n54 VSS.t11 16.5719
R8486 VSS.n54 VSS.t7 16.5719
R8487 VSS.n43 VSS.t3 16.5719
R8488 VSS.n43 VSS.t15 16.5719
R8489 VSS.n97 VSS.t102 16.5719
R8490 VSS.n97 VSS.t112 16.5719
R8491 VSS.n98 VSS.t114 16.5719
R8492 VSS.n98 VSS.t104 16.5719
R8493 VSS.n99 VSS.t108 16.5719
R8494 VSS.n99 VSS.t116 16.5719
R8495 VSS.n21 VSS.t110 16.5719
R8496 VSS.n21 VSS.t106 16.5719
R8497 VSS.n39 VSS.n14 15.8113
R8498 VSS.n60 VSS.n14 15.8113
R8499 VSS.n171 VSS.n15 15.8113
R8500 VSS.n112 VSS.t74 15.3048
R8501 VSS.n172 VSS.t70 15.3048
R8502 VSS.n168 VSS.n167 15.0005
R8503 VSS.n169 VSS.n168 15.0005
R8504 VSS.n94 VSS.n93 15.0005
R8505 VSS.n95 VSS.n94 15.0005
R8506 VSS.n93 VSS.n92 15.0005
R8507 VSS.n92 VSS.n63 15.0005
R8508 VSS.n135 VSS.n134 15.0005
R8509 VSS.n134 VSS.n133 15.0005
R8510 VSS.n203 VSS.n6 13.8811
R8511 VSS.t0 VSS.t60 12.4353
R8512 VSS.t105 VSS.t87 12.4353
R8513 VSS.n48 VSS.n39 11.1532
R8514 VSS.n136 VSS.n135 10.5967
R8515 VSS.n177 VSS.n176 10.5392
R8516 VSS.t73 VSS.n25 9.56572
R8517 VSS.n155 VSS.n154 9.3005
R8518 VSS.n156 VSS.n155 9.3005
R8519 VSS.n204 VSS.n203 9.3005
R8520 VSS.n10 VSS.n0 9.3005
R8521 VSS.n201 VSS.n0 9.3005
R8522 VSS.n10 VSS.n7 9.3005
R8523 VSS.n201 VSS.n7 9.3005
R8524 VSS.n203 VSS.n7 9.3005
R8525 VSS.n10 VSS.n4 9.3005
R8526 VSS.n201 VSS.n4 9.3005
R8527 VSS.n203 VSS.n4 9.3005
R8528 VSS.n202 VSS.n10 9.3005
R8529 VSS.n202 VSS.n201 9.3005
R8530 VSS.n202 VSS.n9 9.3005
R8531 VSS.n203 VSS.n202 9.3005
R8532 VSS.n187 VSS.n186 8.60344
R8533 VSS.n188 VSS.n187 8.60344
R8534 VSS.n190 VSS.n189 8.60344
R8535 VSS.n189 VSS.n188 8.60344
R8536 VSS.n64 VSS.n27 8.35764
R8537 VSS.n61 VSS.n27 8.35764
R8538 VSS.n164 VSS.n28 8.35764
R8539 VSS.n61 VSS.n28 8.35764
R8540 VSS.n91 VSS.n90 7.81306
R8541 VSS.n88 VSS.n45 7.29328
R8542 VSS.n90 VSS.n89 5.22699
R8543 VSS.n89 VSS.n88 4.74889
R8544 VSS.n197 VSS.n196 4.64515
R8545 VSS.n9 VSS.n8 4.64515
R8546 VSS.n198 VSS.n197 4.64515
R8547 VSS.n96 VSS.t84 4.63208
R8548 VSS.n204 VSS.n2 4.53748
R8549 VSS.n5 VSS.n0 4.53748
R8550 VSS.n204 VSS.n1 4.51909
R8551 VSS.n91 VSS.n65 4.1404
R8552 VSS.n135 VSS.n39 3.87389
R8553 VSS.n180 VSS.n179 3.27161
R8554 VSS.n116 VSS.n51 3.25739
R8555 VSS.n120 VSS.n49 3.12939
R8556 VSS.n186 VSS.n16 3.12939
R8557 VSS.n186 VSS.n185 3.12939
R8558 VSS.n185 VSS.n18 3.12939
R8559 VSS.n181 VSS.n180 3.12939
R8560 VSS.n181 VSS.n20 2.6885
R8561 VSS.n116 VSS.n115 2.66006
R8562 VSS.n179 VSS.n175 2.66006
R8563 VSS.n163 VSS.n162 2.64695
R8564 VSS.n162 VSS.n31 2.64695
R8565 VSS.n158 VSS.n31 2.64695
R8566 VSS.n148 VSS.n147 2.56716
R8567 VSS.n127 VSS.n46 2.35108
R8568 VSS.n123 VSS.n122 2.35108
R8569 VSS.n144 VSS.n143 2.32777
R8570 VSS.n141 VSS.n138 2.32777
R8571 VSS.n138 VSS.n13 2.32777
R8572 VSS.n191 VSS.n11 2.32777
R8573 VSS.n195 VSS.n11 2.32777
R8574 VSS.n154 VSS.n153 2.29409
R8575 VSS.n142 VSS.n141 2.20753
R8576 VSS.n150 VSS.n34 2.12207
R8577 VSS.n121 VSS.n120 2.05524
R8578 VSS.n165 VSS.n164 2.04549
R8579 VSS.n150 VSS.n149 1.928
R8580 VSS.n106 VSS.n16 1.9205
R8581 VSS.t17 VSS.t43 1.73734
R8582 VSS.t29 VSS.t19 1.73734
R8583 VSS.t26 VSS.t46 1.73734
R8584 VSS.t21 VSS.t38 1.73734
R8585 VSS.n178 VSS.n177 1.69425
R8586 VSS.n117 VSS.n50 1.69425
R8587 VSS.n105 VSS.n104 1.688
R8588 VSS.n126 VSS.n45 1.688
R8589 VSS.n147 VSS.n136 1.64898
R8590 VSS.n197 VSS.n195 1.62959
R8591 VSS.n127 VSS.n126 1.5505
R8592 VSS.n125 VSS.n46 1.5505
R8593 VSS.n124 VSS.n123 1.5505
R8594 VSS.n122 VSS.n47 1.5505
R8595 VSS.n120 VSS.n119 1.5505
R8596 VSS.n118 VSS.n49 1.5505
R8597 VSS.n117 VSS.n116 1.5505
R8598 VSS.n104 VSS.n16 1.5505
R8599 VSS.n186 VSS.n17 1.5505
R8600 VSS.n185 VSS.n184 1.5505
R8601 VSS.n183 VSS.n18 1.5505
R8602 VSS.n182 VSS.n181 1.5505
R8603 VSS.n180 VSS.n19 1.5505
R8604 VSS.n179 VSS.n178 1.5505
R8605 VSS.n123 VSS.n48 1.54975
R8606 VSS.n128 VSS.n127 1.4429
R8607 VSS.n190 VSS.n13 1.35808
R8608 VSS.n157 VSS.n156 1.32814
R8609 VSS.n106 VSS.n105 1.20939
R8610 VSS.n191 VSS.n190 0.970197
R8611 VSS.n158 VSS.n157 0.966455
R8612 VSS.n128 VSS.n45 0.90868
R8613 VSS.n48 VSS.n46 0.801836
R8614 VSS.n149 VSS.n148 0.719452
R8615 VSS.n164 VSS.n163 0.684166
R8616 VSS.n144 VSS.n136 0.679288
R8617 VSS.n115 VSS.n50 0.612056
R8618 VSS.n177 VSS.n175 0.612056
R8619 VSS.n153 VSS.n34 0.525379
R8620 VSS.n20 VSS.n18 0.441389
R8621 VSS.n156 VSS.n33 0.35336
R8622 VSS.n154 VSS.n33 0.35336
R8623 VSS.n122 VSS.n121 0.331719
R8624 VSS.n9 VSS.n1 0.264813
R8625 VSS.n201 VSS.n1 0.264813
R8626 VSS.n199 VSS.n10 0.233227
R8627 VSS.n10 VSS.n2 0.228046
R8628 VSS.n197 VSS.n2 0.228046
R8629 VSS.n9 VSS.n5 0.228046
R8630 VSS.n203 VSS.n5 0.228046
R8631 VSS.n201 VSS.n200 0.190561
R8632 VSS.n204 VSS.n3 0.148582
R8633 VSS.n178 VSS.n19 0.14425
R8634 VSS.n118 VSS.n117 0.14425
R8635 VSS.n104 VSS.n17 0.138
R8636 VSS.n184 VSS.n17 0.138
R8637 VSS.n184 VSS.n183 0.138
R8638 VSS.n182 VSS.n19 0.138
R8639 VSS.n126 VSS.n125 0.138
R8640 VSS.n125 VSS.n124 0.138
R8641 VSS.n124 VSS.n47 0.138
R8642 VSS.n119 VSS.n118 0.138
R8643 VSS VSS.n32 0.1255
R8644 VSS.n143 VSS.n142 0.120742
R8645 VSS.n200 VSS.n199 0.120742
R8646 VSS.n33 VSS.n32 0.0866111
R8647 VSS.n199 VSS.n3 0.0866111
R8648 VSS.n195 VSS.n194 0.0866111
R8649 VSS.n193 VSS.n11 0.0866111
R8650 VSS.n192 VSS.n191 0.0866111
R8651 VSS.n13 VSS.n12 0.0866111
R8652 VSS.n139 VSS.n138 0.0866111
R8653 VSS.n141 VSS.n140 0.0866111
R8654 VSS.n143 VSS.n137 0.0866111
R8655 VSS.n145 VSS.n144 0.0866111
R8656 VSS.n147 VSS.n146 0.0866111
R8657 VSS.n148 VSS.n35 0.0866111
R8658 VSS.n151 VSS.n150 0.0866111
R8659 VSS.n153 VSS.n152 0.0866111
R8660 VSS.n159 VSS.n158 0.0866111
R8661 VSS.n160 VSS.n31 0.0866111
R8662 VSS.n162 VSS.n161 0.0866111
R8663 VSS.n163 VSS.n30 0.0866111
R8664 VSS.n183 VSS 0.06925
R8665 VSS VSS.n182 0.06925
R8666 VSS VSS.n47 0.06925
R8667 VSS.n119 VSS 0.06925
R8668 VSS.n165 VSS.n30 0.0369003
R8669 VSS.n155 VSS 0.0355
R8670 VSS.n161 VSS.n30 0.0345909
R8671 VSS.n161 VSS.n160 0.0345909
R8672 VSS.n160 VSS.n159 0.0345909
R8673 VSS.n159 VSS.n32 0.0345909
R8674 VSS.n152 VSS.n32 0.0345909
R8675 VSS.n152 VSS.n151 0.0345909
R8676 VSS.n151 VSS.n35 0.0345909
R8677 VSS.n146 VSS.n145 0.0345909
R8678 VSS.n145 VSS.n137 0.0345909
R8679 VSS.n140 VSS.n137 0.0345909
R8680 VSS.n140 VSS.n139 0.0345909
R8681 VSS.n139 VSS.n12 0.0345909
R8682 VSS.n192 VSS.n12 0.0345909
R8683 VSS.n193 VSS.n192 0.0345909
R8684 VSS.n194 VSS.n193 0.0345909
R8685 VSS.n194 VSS.n3 0.0345909
R8686 VSS VSS.n35 0.0232273
R8687 VSS VSS.n0 0.016125
R8688 VSS.n51 VSS.n49 0.0147222
R8689 VSS.n202 VSS.n198 0.012704
R8690 VSS.n8 VSS.n7 0.012704
R8691 VSS.n196 VSS.n0 0.012704
R8692 VSS.n196 VSS.n7 0.012704
R8693 VSS.n198 VSS.n4 0.012704
R8694 VSS.n8 VSS.n4 0.012704
R8695 VSS.n146 VSS 0.0118636
R8696 VSS VSS.n204 0.0083125
R8697 a_816_4748.n5 a_816_4748.n3 202.269
R8698 a_816_4748.n5 a_816_4748.n4 202.266
R8699 a_816_4748.n43 a_816_4748.n42 29.74
R8700 a_816_4748.n11 a_816_4748.n10 29.74
R8701 a_816_4748.n26 a_816_4748.n25 29.74
R8702 a_816_4748.n65 a_816_4748.n64 29.74
R8703 a_816_4748.n3 a_816_4748.t9 17.3126
R8704 a_816_4748.n3 a_816_4748.t10 17.3126
R8705 a_816_4748.n4 a_816_4748.t11 17.3126
R8706 a_816_4748.n4 a_816_4748.t8 17.3126
R8707 a_816_4748.n50 a_816_4748.n49 4.5005
R8708 a_816_4748.n41 a_816_4748.n40 4.5005
R8709 a_816_4748.n45 a_816_4748.n44 4.5005
R8710 a_816_4748.n18 a_816_4748.n17 4.5005
R8711 a_816_4748.n9 a_816_4748.n8 4.5005
R8712 a_816_4748.n13 a_816_4748.n12 4.5005
R8713 a_816_4748.n33 a_816_4748.n32 4.5005
R8714 a_816_4748.n24 a_816_4748.n23 4.5005
R8715 a_816_4748.n28 a_816_4748.n27 4.5005
R8716 a_816_4748.n59 a_816_4748.n2 4.5005
R8717 a_816_4748.n61 a_816_4748.n60 4.5005
R8718 a_816_4748.n62 a_816_4748.n0 4.5005
R8719 a_816_4748.n42 a_816_4748.t6 4.08121
R8720 a_816_4748.n42 a_816_4748.t0 4.08121
R8721 a_816_4748.n10 a_816_4748.t1 4.08121
R8722 a_816_4748.n10 a_816_4748.t4 4.08121
R8723 a_816_4748.n25 a_816_4748.t5 4.08121
R8724 a_816_4748.n25 a_816_4748.t2 4.08121
R8725 a_816_4748.t3 a_816_4748.n65 4.08121
R8726 a_816_4748.n65 a_816_4748.t7 4.08121
R8727 a_816_4748.n52 a_816_4748.n51 3.47871
R8728 a_816_4748.n20 a_816_4748.n19 3.47871
R8729 a_816_4748.n35 a_816_4748.n34 3.47871
R8730 a_816_4748.n58 a_816_4748.n54 3.47871
R8731 a_816_4748.n47 a_816_4748.n41 3.4105
R8732 a_816_4748.n49 a_816_4748.n48 3.4105
R8733 a_816_4748.n39 a_816_4748.n38 3.4105
R8734 a_816_4748.n15 a_816_4748.n9 3.4105
R8735 a_816_4748.n17 a_816_4748.n16 3.4105
R8736 a_816_4748.n7 a_816_4748.n6 3.4105
R8737 a_816_4748.n30 a_816_4748.n24 3.4105
R8738 a_816_4748.n32 a_816_4748.n31 3.4105
R8739 a_816_4748.n22 a_816_4748.n21 3.4105
R8740 a_816_4748.n61 a_816_4748.n1 3.4105
R8741 a_816_4748.n55 a_816_4748.n2 3.4105
R8742 a_816_4748.n57 a_816_4748.n56 3.4105
R8743 a_816_4748.n51 a_816_4748.n50 2.38642
R8744 a_816_4748.n19 a_816_4748.n18 2.38642
R8745 a_816_4748.n34 a_816_4748.n33 2.38642
R8746 a_816_4748.n59 a_816_4748.n58 2.38642
R8747 a_816_4748.n46 a_816_4748.n43 1.34877
R8748 a_816_4748.n14 a_816_4748.n11 1.34877
R8749 a_816_4748.n29 a_816_4748.n26 1.34877
R8750 a_816_4748.n64 a_816_4748.n63 1.3479
R8751 a_816_4748.n63 a_816_4748.n1 0.757265
R8752 a_816_4748.n47 a_816_4748.n46 0.756722
R8753 a_816_4748.n15 a_816_4748.n14 0.756722
R8754 a_816_4748.n30 a_816_4748.n29 0.756722
R8755 a_816_4748.n37 a_816_4748.n5 0.244045
R8756 a_816_4748.n53 a_816_4748.n52 0.206837
R8757 a_816_4748.n36 a_816_4748.n20 0.206837
R8758 a_816_4748.n46 a_816_4748.n45 0.177197
R8759 a_816_4748.n14 a_816_4748.n13 0.177197
R8760 a_816_4748.n29 a_816_4748.n28 0.177197
R8761 a_816_4748.n63 a_816_4748.n62 0.177161
R8762 a_816_4748.n50 a_816_4748.n40 0.135917
R8763 a_816_4748.n44 a_816_4748.n40 0.135917
R8764 a_816_4748.n49 a_816_4748.n39 0.135917
R8765 a_816_4748.n49 a_816_4748.n41 0.135917
R8766 a_816_4748.n45 a_816_4748.n41 0.135917
R8767 a_816_4748.n18 a_816_4748.n8 0.135917
R8768 a_816_4748.n12 a_816_4748.n8 0.135917
R8769 a_816_4748.n17 a_816_4748.n7 0.135917
R8770 a_816_4748.n17 a_816_4748.n9 0.135917
R8771 a_816_4748.n13 a_816_4748.n9 0.135917
R8772 a_816_4748.n33 a_816_4748.n23 0.135917
R8773 a_816_4748.n27 a_816_4748.n23 0.135917
R8774 a_816_4748.n32 a_816_4748.n22 0.135917
R8775 a_816_4748.n32 a_816_4748.n24 0.135917
R8776 a_816_4748.n28 a_816_4748.n24 0.135917
R8777 a_816_4748.n57 a_816_4748.n2 0.135917
R8778 a_816_4748.n61 a_816_4748.n2 0.135917
R8779 a_816_4748.n62 a_816_4748.n61 0.135917
R8780 a_816_4748.n60 a_816_4748.n59 0.135917
R8781 a_816_4748.n60 a_816_4748.n0 0.135917
R8782 a_816_4748.n36 a_816_4748.n35 0.104292
R8783 a_816_4748.n54 a_816_4748.n53 0.104292
R8784 a_816_4748.n44 a_816_4748.n43 0.0755
R8785 a_816_4748.n12 a_816_4748.n11 0.0755
R8786 a_816_4748.n27 a_816_4748.n26 0.0755
R8787 a_816_4748.n64 a_816_4748.n0 0.0755
R8788 a_816_4748.n51 a_816_4748.n39 0.0667303
R8789 a_816_4748.n19 a_816_4748.n7 0.0667303
R8790 a_816_4748.n34 a_816_4748.n22 0.0667303
R8791 a_816_4748.n58 a_816_4748.n57 0.0667303
R8792 a_816_4748.n53 a_816_4748.n37 0.0539091
R8793 a_816_4748.n52 a_816_4748.n38 0.0514167
R8794 a_816_4748.n48 a_816_4748.n38 0.0514167
R8795 a_816_4748.n48 a_816_4748.n47 0.0514167
R8796 a_816_4748.n20 a_816_4748.n6 0.0514167
R8797 a_816_4748.n16 a_816_4748.n6 0.0514167
R8798 a_816_4748.n16 a_816_4748.n15 0.0514167
R8799 a_816_4748.n35 a_816_4748.n21 0.0514167
R8800 a_816_4748.n31 a_816_4748.n21 0.0514167
R8801 a_816_4748.n31 a_816_4748.n30 0.0514167
R8802 a_816_4748.n56 a_816_4748.n54 0.0514167
R8803 a_816_4748.n56 a_816_4748.n55 0.0514167
R8804 a_816_4748.n55 a_816_4748.n1 0.0514167
R8805 a_816_4748.n37 a_816_4748.n36 0.0496364
R8806 divider-feedback_0.VFB divider-feedback_0.VFB.t1 23.9852
R8807 divider-feedback_0.VFB divider-feedback_0.VFB.t0 3.8049
R8808 VDD.n11 VDD.n4 21481.9
R8809 VDD.n11 VDD.n10 21244.4
R8810 VDD.n9 VDD.n4 19320.6
R8811 VDD.n10 VDD.n9 19130.6
R8812 VDD.n12 VDD.n2 5607
R8813 VDD.n12 VDD.n3 5547
R8814 VDD.n8 VDD.n2 5061
R8815 VDD.n8 VDD.n3 5013
R8816 VDD.n7 VDD.n0 539.841
R8817 VDD.n13 VDD.n1 381.233
R8818 VDD.n14 VDD.n13 320.32
R8819 VDD.n7 VDD.n6 316.82
R8820 VDD.n14 VDD.n0 277.76
R8821 VDD.n15 VDD.n14 131.189
R8822 VDD.n15 VDD.t0 22.044
R8823 VDD.n6 VDD.n5 2.99332
R8824 VDD.n5 VDD.n1 0.666019
R8825 VDD.n8 VDD.n7 0.175855
R8826 VDD.n9 VDD.n8 0.175855
R8827 VDD.n13 VDD.n12 0.175855
R8828 VDD.n12 VDD.n11 0.175855
R8829 VDD.n2 VDD.n0 0.164944
R8830 VDD.n4 VDD.n2 0.164944
R8831 VDD.n5 VDD.n3 0.164944
R8832 VDD.n10 VDD.n3 0.164944
R8833 VDD VDD.n15 0.0489779
R8834 VDD.n6 VDD 0.0268976
R8835 VDD VDD.n1 0.0144056
R8836 bias-network_0.IBIAS2.n9 bias-network_0.IBIAS2.t12 253.282
R8837 bias-network_0.IBIAS2.n8 bias-network_0.IBIAS2.t16 253.282
R8838 bias-network_0.IBIAS2.n7 bias-network_0.IBIAS2.t19 253.282
R8839 bias-network_0.IBIAS2.n6 bias-network_0.IBIAS2.t14 253.282
R8840 bias-network_0.IBIAS2.n3 bias-network_0.IBIAS2.t10 253.282
R8841 bias-network_0.IBIAS2.n2 bias-network_0.IBIAS2.t18 253.282
R8842 bias-network_0.IBIAS2.n1 bias-network_0.IBIAS2.t17 253.282
R8843 bias-network_0.IBIAS2.n0 bias-network_0.IBIAS2.t8 253.282
R8844 bias-network_0.IBIAS2.n0 bias-network_0.IBIAS2.t9 215.909
R8845 bias-network_0.IBIAS2.n10 bias-network_0.IBIAS2.t13 215.798
R8846 bias-network_0.IBIAS2.n5 bias-network_0.IBIAS2.n4 198.368
R8847 bias-network_0.IBIAS2.n12 bias-network_0.IBIAS2.t3 120.692
R8848 bias-network_0.IBIAS2.n13 bias-network_0.IBIAS2.t2 120.692
R8849 bias-network_0.IBIAS2.n12 bias-network_0.IBIAS2.t1 120.477
R8850 bias-network_0.IBIAS2.n13 bias-network_0.IBIAS2.t0 120.477
R8851 bias-network_0.IBIAS2.n16 bias-network_0.IBIAS2.n14 97.492
R8852 bias-network_0.IBIAS2.n16 bias-network_0.IBIAS2.n15 97.2768
R8853 bias-network_0.IBIAS2.n15 bias-network_0.IBIAS2.t6 23.2005
R8854 bias-network_0.IBIAS2.n15 bias-network_0.IBIAS2.t4 23.2005
R8855 bias-network_0.IBIAS2.n14 bias-network_0.IBIAS2.t7 23.2005
R8856 bias-network_0.IBIAS2.n14 bias-network_0.IBIAS2.t5 23.2005
R8857 bias-network_0.IBIAS2.n4 bias-network_0.IBIAS2.t11 17.3126
R8858 bias-network_0.IBIAS2.n4 bias-network_0.IBIAS2.t15 17.3126
R8859 bias-network_0.IBIAS2 bias-network_0.IBIAS2.n11 11.1097
R8860 bias-network_0.IBIAS2.n11 bias-network_0.IBIAS2 2.3135
R8861 bias-network_0.IBIAS2.n17 bias-network_0.IBIAS2.n13 2.22599
R8862 bias-network_0.IBIAS2.n11 bias-network_0.IBIAS2.n10 2.10291
R8863 bias-network_0.IBIAS2.n18 bias-network_0.IBIAS2.n17 1.46479
R8864 bias-network_0.IBIAS2.n18 bias-network_0.IBIAS2.n12 0.7617
R8865 bias-network_0.IBIAS2.n17 bias-network_0.IBIAS2.n16 0.7617
R8866 bias-network_0.IBIAS2 bias-network_0.IBIAS2.n18 0.640873
R8867 bias-network_0.IBIAS2.n1 bias-network_0.IBIAS2.n0 0.223
R8868 bias-network_0.IBIAS2.n2 bias-network_0.IBIAS2.n1 0.223
R8869 bias-network_0.IBIAS2.n3 bias-network_0.IBIAS2.n2 0.223
R8870 bias-network_0.IBIAS2.n7 bias-network_0.IBIAS2.n6 0.223
R8871 bias-network_0.IBIAS2.n8 bias-network_0.IBIAS2.n7 0.223
R8872 bias-network_0.IBIAS2.n9 bias-network_0.IBIAS2.n8 0.223
R8873 bias-network_0.IBIAS2.n10 bias-network_0.IBIAS2.n9 0.108
R8874 bias-network_0.IBIAS2.n5 bias-network_0.IBIAS2.n3 0.048
R8875 bias-network_0.IBIAS2.n6 bias-network_0.IBIAS2.n5 0.038
R8876 a_638_4130.n48 a_638_4130.t8 203.476
R8877 a_638_4130.n49 a_638_4130.t12 203.476
R8878 a_638_4130.n50 a_638_4130.t15 203.476
R8879 a_638_4130.n51 a_638_4130.t10 203.476
R8880 a_638_4130.n46 a_638_4130.t6 203.476
R8881 a_638_4130.n45 a_638_4130.t14 203.476
R8882 a_638_4130.n44 a_638_4130.t13 203.476
R8883 a_638_4130.n43 a_638_4130.t4 203.476
R8884 a_638_4130.n42 a_638_4130.t5 81.3798
R8885 a_638_4130.n47 a_638_4130.t9 81.3797
R8886 a_638_4130.n41 a_638_4130.n40 64.7672
R8887 a_638_4130.n28 a_638_4130.t2 33.8207
R8888 a_638_4130.n11 a_638_4130.t0 33.8207
R8889 a_638_4130.n70 a_638_4130.n69 29.74
R8890 a_638_4130.n40 a_638_4130.t7 16.5719
R8891 a_638_4130.n40 a_638_4130.t11 16.5719
R8892 a_638_4130.n55 a_638_4130.n41 4.59425
R8893 a_638_4130.n29 a_638_4130.n27 4.5005
R8894 a_638_4130.n31 a_638_4130.n30 4.5005
R8895 a_638_4130.n25 a_638_4130.n24 4.5005
R8896 a_638_4130.n36 a_638_4130.n35 4.5005
R8897 a_638_4130.n19 a_638_4130.n18 4.5005
R8898 a_638_4130.n8 a_638_4130.n7 4.5005
R8899 a_638_4130.n14 a_638_4130.n13 4.5005
R8900 a_638_4130.n12 a_638_4130.n10 4.5005
R8901 a_638_4130.n54 a_638_4130.n53 4.5005
R8902 a_638_4130.n63 a_638_4130.n4 4.5005
R8903 a_638_4130.n65 a_638_4130.n64 4.5005
R8904 a_638_4130.n66 a_638_4130.n1 4.5005
R8905 a_638_4130.n68 a_638_4130.n67 4.5005
R8906 a_638_4130.n42 a_638_4130.n39 4.2667
R8907 a_638_4130.n47 a_638_4130.n39 4.26246
R8908 a_638_4130.t3 a_638_4130.n70 4.08121
R8909 a_638_4130.n70 a_638_4130.t1 4.08121
R8910 a_638_4130.n21 a_638_4130.n20 3.47871
R8911 a_638_4130.n62 a_638_4130.n58 3.47871
R8912 a_638_4130.n38 a_638_4130.n37 3.47869
R8913 a_638_4130.n54 a_638_4130.n39 3.4152
R8914 a_638_4130.n23 a_638_4130.n22 3.4105
R8915 a_638_4130.n35 a_638_4130.n34 3.4105
R8916 a_638_4130.n33 a_638_4130.n25 3.4105
R8917 a_638_4130.n32 a_638_4130.n31 3.4105
R8918 a_638_4130.n6 a_638_4130.n5 3.4105
R8919 a_638_4130.n18 a_638_4130.n17 3.4105
R8920 a_638_4130.n16 a_638_4130.n8 3.4105
R8921 a_638_4130.n15 a_638_4130.n14 3.4105
R8922 a_638_4130.n56 a_638_4130.n55 3.4105
R8923 a_638_4130.n61 a_638_4130.n60 3.4105
R8924 a_638_4130.n59 a_638_4130.n4 3.4105
R8925 a_638_4130.n65 a_638_4130.n3 3.4105
R8926 a_638_4130.n66 a_638_4130.n2 3.4105
R8927 a_638_4130.n20 a_638_4130.n19 2.38642
R8928 a_638_4130.n63 a_638_4130.n62 2.38642
R8929 a_638_4130.n37 a_638_4130.n36 2.38366
R8930 a_638_4130.n69 a_638_4130.n0 1.22622
R8931 a_638_4130.n11 a_638_4130.n9 1.22589
R8932 a_638_4130.n28 a_638_4130.n26 1.22159
R8933 a_638_4130.n15 a_638_4130.n9 0.660172
R8934 a_638_4130.n32 a_638_4130.n26 0.660076
R8935 a_638_4130.n2 a_638_4130.n0 0.659967
R8936 a_638_4130.n44 a_638_4130.n43 0.384121
R8937 a_638_4130.n45 a_638_4130.n44 0.384121
R8938 a_638_4130.n46 a_638_4130.n45 0.384121
R8939 a_638_4130.n51 a_638_4130.n50 0.384121
R8940 a_638_4130.n50 a_638_4130.n49 0.384121
R8941 a_638_4130.n49 a_638_4130.n48 0.384121
R8942 a_638_4130.n57 a_638_4130.n38 0.27164
R8943 a_638_4130.n57 a_638_4130.n21 0.27164
R8944 a_638_4130.n43 a_638_4130.n42 0.24901
R8945 a_638_4130.n48 a_638_4130.n47 0.244753
R8946 a_638_4130.n57 a_638_4130.n56 0.219442
R8947 a_638_4130.n27 a_638_4130.n26 0.204016
R8948 a_638_4130.n67 a_638_4130.n0 0.203935
R8949 a_638_4130.n10 a_638_4130.n9 0.203925
R8950 a_638_4130.n55 a_638_4130.n54 0.1755
R8951 a_638_4130.n31 a_638_4130.n27 0.135917
R8952 a_638_4130.n31 a_638_4130.n25 0.135917
R8953 a_638_4130.n35 a_638_4130.n25 0.135917
R8954 a_638_4130.n35 a_638_4130.n23 0.135917
R8955 a_638_4130.n13 a_638_4130.n12 0.135917
R8956 a_638_4130.n13 a_638_4130.n7 0.135917
R8957 a_638_4130.n19 a_638_4130.n7 0.135917
R8958 a_638_4130.n14 a_638_4130.n10 0.135917
R8959 a_638_4130.n14 a_638_4130.n8 0.135917
R8960 a_638_4130.n18 a_638_4130.n8 0.135917
R8961 a_638_4130.n18 a_638_4130.n6 0.135917
R8962 a_638_4130.n67 a_638_4130.n66 0.135917
R8963 a_638_4130.n66 a_638_4130.n65 0.135917
R8964 a_638_4130.n65 a_638_4130.n4 0.135917
R8965 a_638_4130.n61 a_638_4130.n4 0.135917
R8966 a_638_4130.n68 a_638_4130.n1 0.135917
R8967 a_638_4130.n64 a_638_4130.n1 0.135917
R8968 a_638_4130.n64 a_638_4130.n63 0.135917
R8969 a_638_4130.n30 a_638_4130.n29 0.133697
R8970 a_638_4130.n30 a_638_4130.n24 0.133697
R8971 a_638_4130.n36 a_638_4130.n24 0.133697
R8972 a_638_4130.n53 a_638_4130.n52 0.12675
R8973 a_638_4130.n52 a_638_4130.n51 0.0867069
R8974 a_638_4130.n52 a_638_4130.n46 0.0823966
R8975 a_638_4130.n53 a_638_4130.n41 0.08175
R8976 a_638_4130.n37 a_638_4130.n23 0.0667461
R8977 a_638_4130.n20 a_638_4130.n6 0.0667303
R8978 a_638_4130.n62 a_638_4130.n61 0.0667303
R8979 a_638_4130.n33 a_638_4130.n32 0.0514167
R8980 a_638_4130.n34 a_638_4130.n33 0.0514167
R8981 a_638_4130.n34 a_638_4130.n22 0.0514167
R8982 a_638_4130.n38 a_638_4130.n22 0.0514167
R8983 a_638_4130.n16 a_638_4130.n15 0.0514167
R8984 a_638_4130.n17 a_638_4130.n16 0.0514167
R8985 a_638_4130.n17 a_638_4130.n5 0.0514167
R8986 a_638_4130.n21 a_638_4130.n5 0.0514167
R8987 a_638_4130.n3 a_638_4130.n2 0.0514167
R8988 a_638_4130.n59 a_638_4130.n3 0.0514167
R8989 a_638_4130.n60 a_638_4130.n59 0.0514167
R8990 a_638_4130.n60 a_638_4130.n58 0.0514167
R8991 a_638_4130.n56 a_638_4130.n39 0.0099
R8992 a_638_4130.n12 a_638_4130.n11 0.00883333
R8993 a_638_4130.n69 a_638_4130.n68 0.00883333
R8994 a_638_4130.n29 a_638_4130.n28 0.00869672
R8995 a_638_4130.n58 a_638_4130.n57 0.00245833
C0 m1_11200_16780# VIN 6.24723f
C1 bias-network_0.IBIAS2 a_n100_2480# 0.00888f
C2 a_10552_2090# a_10752_310# 0.007f
C3 a_900_2480# OUT 0.02563f
C4 a_2500_2480# a_3100_2480# 0.41021f
C5 a_9952_310# a_10152_2090# 0.00706f
C6 a_11152_310# a_11552_310# 0.42336f
C7 divider-feedback_0.VFB a_3100_2480# 0.20796f
C8 bias-network_0.VREF VIN 9.59259f
C9 a_8532_2090# VIN 0.00722f
C10 a_1100_700# a_1500_2480# 0.00256f
C11 a_8952_2090# a_9352_2090# 0.42336f
C12 bias-network_0.IBIAS2 a_100_2480# 0
C13 a_8152_2090# OUT 0.01354f
C14 a_2500_2480# a_3300_2480# 0.04936f
C15 error-amplifier_0.VN bias-network_0.VREF 2.68521f
C16 a_11352_2090# a_11752_2090# 0.42336f
C17 a_n100_2480# a_300_700# 0.00256f
C18 divider-feedback_0.VFB a_3300_2480# 0.03411f
C19 bias-network_0.IBIAS2 a_8352_310# 0
C20 a_10152_2090# OUT 0.01354f
C21 a_1900_700# OUT 0.00563f
C22 a_9552_310# a_9952_310# 0.37792f
C23 a_10752_310# a_10952_2090# 0.00706f
C24 a_2100_700# a_2700_700# 0.40811f
C25 a_1700_2480# a_2100_700# 0.01162f
C26 a_2900_700# OUT 0.00277f
C27 error-amplifier_0.VN divider-feedback_0.VFB 0.10004f
C28 a_700_2480# a_1500_2480# 0.03018f
C29 bias-network_0.IBIAS2 a_700_2480# 0.00888f
C30 a_300_700# a_1100_700# 0.03187f
C31 divider-feedback_0.VFB a_1300_700# 0.01552f
C32 a_1500_2480# a_2300_2480# 0.03018f
C33 bias-network_0.VREF a_9152_310# 0
C34 bias-network_0.IBIAS2 a_2300_2480# 0.00888f
C35 a_8752_310# a_8952_2090# 0.00706f
C36 a_300_700# a_500_700# 1.28159f
C37 a_100_2480# a_300_700# 0.00748f
C38 a_11752_2090# VDD 0.00699f
C39 bias-network_0.IBIAS2 bias-network_0.VREF 3.60264f
C40 a_9732_2090# a_9952_310# 0.007f
C41 a_2300_2480# a_2700_700# 0.00256f
C42 a_8152_2090# VIN 0.00685f
C43 a_1700_2480# a_2300_2480# 0.41025f
C44 a_3100_2480# OUT 0.03601f
C45 bias-network_0.IBIAS2 a_2500_2480# 0
C46 a_900_2480# a_1300_700# 0.01162f
C47 divider-feedback_0.VFB a_1500_2480# 0.18014f
C48 bias-network_0.IBIAS2 divider-feedback_0.VFB 2.27456f
C49 a_2900_700# a_3100_2480# 0.00769f
C50 a_10152_2090# a_10552_2090# 0.42336f
C51 a_300_700# a_700_2480# 0.00256f
C52 a_10552_2090# OUT 0.01554f
C53 a_8352_310# a_8752_310# 0.37792f
C54 a_10952_2090# a_11152_310# 0.007f
C55 a_10152_2090# VIN 0.00685f
C56 VIN OUT 0.3272p
C57 a_n100_2480# a_100_2480# 1.29039f
C58 a_2500_2480# a_2700_700# 0.00748f
C59 a_1700_2480# a_2500_2480# 0.04936f
C60 a_9732_2090# a_10152_2090# 0.42336f
C61 a_3300_2480# OUT 0.03375f
C62 a_9732_2090# OUT 0.0142f
C63 divider-feedback_0.VFB a_2700_700# 0.13664f
C64 divider-feedback_0.VFB a_1700_2480# 0.01751f
C65 a_2900_700# a_3300_2480# 0.01162f
C66 a_900_2480# a_1500_2480# 0.41025f
C67 bias-network_0.IBIAS2 a_900_2480# 0
C68 a_500_700# a_1100_700# 0.40811f
C69 bias-network_0.IBIAS1 a_2300_2480# 0.01653f
C70 m1_11200_16780# VDD 0.0997f
C71 error-amplifier_0.VN OUT 0.04319f
C72 a_1300_700# a_1900_700# 0.40811f
C73 bias-network_0.VREF a_8752_310# 0.00166f
C74 a_1300_700# OUT 0.00345f
C75 a_100_2480# a_500_700# 0.01162f
C76 divider-feedback_0.VFB a_300_700# 0.60228f
C77 a_8532_2090# a_8752_310# 0.007f
C78 a_n100_2480# a_700_2480# 0.03018f
C79 bias-network_0.IBIAS1 bias-network_0.VREF 7.779f
C80 a_10952_2090# OUT 0.01354f
C81 a_9552_310# a_9732_2090# 0.00727f
C82 a_900_2480# a_1700_2480# 0.04936f
C83 bias-network_0.IBIAS1 a_2500_2480# 0
C84 a_3100_2480# a_3300_2480# 1.28797f
C85 a_10552_2090# VIN 0.00205f
C86 a_11152_310# a_11352_2090# 0.00706f
C87 bias-network_0.IBIAS1 divider-feedback_0.VFB 0.00251f
C88 a_700_2480# a_1100_700# 0.00256f
C89 a_500_700# a_700_2480# 0.0077f
C90 a_1500_2480# a_1900_700# 0.00256f
C91 bias-network_0.VREF a_8952_2090# 0.00111f
C92 a_1500_2480# OUT 0.0354f
C93 a_8532_2090# a_8952_2090# 0.42336f
C94 a_100_2480# a_700_2480# 0.41025f
C95 bias-network_0.IBIAS2 OUT 0.46369f
C96 a_10352_310# a_10752_310# 0.42336f
C97 a_2100_700# a_2300_2480# 0.0077f
C98 bias-network_0.IBIAS2 a_2900_700# 0
C99 a_9732_2090# VIN 0.00722f
C100 a_n100_2480# divider-feedback_0.VFB 0.18241f
C101 a_9352_2090# OUT 0.01364f
C102 a_9152_310# a_9552_310# 0.42336f
C103 error-amplifier_0.VN VIN 1.81355f
C104 a_1900_700# a_2700_700# 0.03187f
C105 a_1700_2480# a_1900_700# 0.00748f
C106 a_2700_700# OUT 0.00563f
C107 a_1700_2480# OUT 0.02563f
C108 divider-feedback_0.VFB a_1100_700# 0.10292f
C109 a_2700_700# a_2900_700# 1.28159f
C110 a_10552_2090# a_10952_2090# 0.42336f
C111 a_2100_700# a_2500_2480# 0.01162f
C112 divider-feedback_0.VFB a_500_700# 0.01623f
C113 a_11352_2090# OUT 0.01354f
C114 bias-network_0.VREF a_8352_310# 0.42515f
C115 a_8352_310# a_8532_2090# 0.00727f
C116 a_100_2480# divider-feedback_0.VFB 0.02607f
C117 divider-feedback_0.VFB a_2100_700# 0.01552f
C118 a_300_700# OUT 0.00749f
C119 bias-network_0.IBIAS2 a_3100_2480# 0.00984f
C120 a_10952_2090# VIN 0.00685f
C121 a_11352_2090# a_11552_310# 0.007f
C122 a_9352_2090# a_9552_310# 0.007f
C123 bias-network_0.IBIAS2 VIN 3.4922f
C124 a_900_2480# a_1100_700# 0.00748f
C125 a_500_700# a_900_2480# 0.01162f
C126 bias-network_0.IBIAS1 OUT 19.453f
C127 a_2700_700# a_3100_2480# 0.00256f
C128 a_2300_2480# a_2500_2480# 1.29396f
C129 a_9952_310# a_10352_310# 0.42336f
C130 bias-network_0.IBIAS2 a_3300_2480# 0.00173f
C131 a_100_2480# a_900_2480# 0.04936f
C132 divider-feedback_0.VFB a_700_2480# 0.18014f
C133 bias-network_0.VREF a_8532_2090# 0.00275f
C134 divider-feedback_0.VFB a_2300_2480# 0.18065f
C135 VDD OUT 6.79953f
C136 a_9352_2090# VIN 0.00661f
C137 a_11552_310# VDD 0.42534f
C138 bias-network_0.IBIAS2 error-amplifier_0.VN 1.8352f
C139 a_n100_2480# OUT 0.04556f
C140 a_1300_700# a_1500_2480# 0.0077f
C141 a_11752_2090# OUT 0.01354f
C142 bias-network_0.VREF divider-feedback_0.VFB 0.00199f
C143 a_9352_2090# a_9732_2090# 0.51547f
C144 a_8952_2090# OUT 0.01495f
C145 a_11352_2090# VIN 0.00685f
C146 a_11552_310# a_11752_2090# 0.00706f
C147 divider-feedback_0.VFB a_2500_2480# 0.01868f
C148 a_700_2480# a_900_2480# 1.294f
C149 a_10152_2090# a_10352_310# 0.007f
C150 a_1100_700# a_1900_700# 0.03187f
C151 a_1100_700# OUT 0.00563f
C152 bias-network_0.IBIAS1 a_3100_2480# 0.00292f
C153 a_500_700# OUT 0.00502f
C154 a_8152_2090# a_8352_310# 0.007f
C155 a_100_2480# OUT 0.02985f
C156 a_10752_310# a_11152_310# 0.42336f
C157 a_1900_700# a_2100_700# 1.28159f
C158 a_2100_700# OUT 0.00345f
C159 a_1300_700# a_1700_2480# 0.01162f
C160 a_2100_700# a_2900_700# 0.05401f
C161 bias-network_0.IBIAS2 a_1500_2480# 0.00888f
C162 a_9152_310# a_9352_2090# 0.00706f
C163 bias-network_0.IBIAS1 VIN 7.88098f
C164 bias-network_0.IBIAS1 a_3300_2480# 0
C165 VDD VIN 4.4783f
C166 divider-feedback_0.VFB a_900_2480# 0.01751f
C167 a_10952_2090# a_11352_2090# 0.42336f
C168 m1_11200_16780# OUT 0.04669f
C169 bias-network_0.VREF a_8152_2090# 0.01473f
C170 a_700_2480# OUT 0.03641f
C171 a_8152_2090# a_8532_2090# 0.51547f
C172 a_1900_700# a_2300_2480# 0.00256f
C173 a_1500_2480# a_1700_2480# 1.294f
C174 a_2300_2480# OUT 0.0354f
C175 a_11752_2090# VIN 0.00685f
C176 bias-network_0.IBIAS2 a_1700_2480# 0
C177 bias-network_0.IBIAS1 error-amplifier_0.VN 0.13519f
C178 a_8952_2090# VIN 0.00344f
C179 a_10352_310# a_10552_2090# 0.00706f
C180 bias-network_0.VREF OUT 1.83741f
C181 a_8532_2090# OUT 0.0142f
C182 a_8752_310# a_9152_310# 0.42336f
C183 a_2500_2480# OUT 0.02564f
C184 divider-feedback_0.VFB a_1900_700# 0.10292f
C185 divider-feedback_0.VFB OUT 1.37112f
C186 a_2500_2480# a_2900_700# 0.01165f
C187 divider-feedback_0.VFB a_2900_700# 0.43104f
C188 bias-network_0.IBIAS2 bias-network_0.IBIAS1 1.31272f
C189 a_2300_2480# a_3100_2480# 0.03018f
C190 a_1100_700# a_1300_700# 1.28159f
C191 a_500_700# a_1300_700# 0.05401f
C192 bias-network_0.IBIAS2 VDD 0.01818f
C193 a_8952_2090# a_9152_310# 0.007f
C194 a_1300_700# a_2100_700# 0.05401f
C195 OUT VSS 41.13088f
C196 VIN VSS 0.33528p
C197 VDD VSS 0.22017p
C198 m1_11200_16780# VSS 2.38709f $ **FLOATING
C199 a_11752_2090# VSS 0.70046f
C200 a_11552_310# VSS 0.42061f
C201 a_11352_2090# VSS 0.41523f
C202 a_11152_310# VSS 0.41744f
C203 a_10952_2090# VSS 0.41522f
C204 a_10752_310# VSS 0.41742f
C205 a_10552_2090# VSS 0.4152f
C206 a_10352_310# VSS 0.4174f
C207 a_10152_2090# VSS 0.4152f
C208 a_9952_310# VSS 0.42533f
C209 a_9732_2090# VSS 0.43092f
C210 a_9552_310# VSS 0.4088f
C211 a_9352_2090# VSS 0.40487f
C212 a_9152_310# VSS 0.41742f
C213 a_8952_2090# VSS 0.41522f
C214 a_8752_310# VSS 0.42537f
C215 a_8532_2090# VSS 0.43095f
C216 a_8352_310# VSS 0.40932f
C217 a_8152_2090# VSS 0.71877f
C218 a_3300_2480# VSS 0.97148f
C219 a_3100_2480# VSS 0.7622f
C220 a_2900_700# VSS 0.57235f
C221 a_2700_700# VSS 0.66331f
C222 a_2500_2480# VSS 0.53173f
C223 a_2300_2480# VSS 0.70453f
C224 a_2100_700# VSS 0.53054f
C225 a_1900_700# VSS 0.66248f
C226 a_1700_2480# VSS 0.53018f
C227 a_1500_2480# VSS 0.71913f
C228 a_1300_700# VSS 0.53048f
C229 a_1100_700# VSS 0.66259f
C230 a_900_2480# VSS 0.53043f
C231 a_700_2480# VSS 0.71972f
C232 a_500_700# VSS 0.57493f
C233 a_300_700# VSS 0.65026f
C234 divider-feedback_0.VFB VSS 9.28985f
C235 a_100_2480# VSS 0.57038f
C236 a_n100_2480# VSS 1.17574f
C237 bias-network_0.VREF VSS 33.24214f
C238 error-amplifier_0.VN VSS 2.08847f
C239 bias-network_0.IBIAS1 VSS 16.09978f
C240 bias-network_0.IBIAS2 VSS 9.5524f
C241 a_638_4130.t1 VSS 0.08197f
C242 a_638_4130.n0 VSS 0.35407f
C243 a_638_4130.n1 VSS 0.06299f
C244 a_638_4130.n2 VSS 0.39247f
C245 a_638_4130.n3 VSS 0.06299f
C246 a_638_4130.n4 VSS 0.06299f
C247 a_638_4130.n5 VSS 0.06299f
C248 a_638_4130.n6 VSS 0.06299f
C249 a_638_4130.n7 VSS 0.06299f
C250 a_638_4130.n8 VSS 0.06299f
C251 a_638_4130.n9 VSS 0.35404f
C252 a_638_4130.n10 VSS 0.11263f
C253 a_638_4130.t0 VSS 0.30102f
C254 a_638_4130.n11 VSS 0.51718f
C255 a_638_4130.n12 VSS 0.03344f
C256 a_638_4130.n13 VSS 0.06299f
C257 a_638_4130.n14 VSS 0.06299f
C258 a_638_4130.n15 VSS 0.39253f
C259 a_638_4130.n16 VSS 0.06299f
C260 a_638_4130.n17 VSS 0.06299f
C261 a_638_4130.n18 VSS 0.06299f
C262 a_638_4130.n19 VSS 0.17788f
C263 a_638_4130.n20 VSS 0.06803f
C264 a_638_4130.n21 VSS 0.2005f
C265 a_638_4130.n22 VSS 0.06299f
C266 a_638_4130.n23 VSS 0.06299f
C267 a_638_4130.n24 VSS 0.06404f
C268 a_638_4130.n25 VSS 0.06299f
C269 a_638_4130.n26 VSS 0.35368f
C270 a_638_4130.n27 VSS 0.11266f
C271 a_638_4130.t2 VSS 0.30102f
C272 a_638_4130.n28 VSS 0.52133f
C273 a_638_4130.n29 VSS 0.03399f
C274 a_638_4130.n30 VSS 0.06404f
C275 a_638_4130.n31 VSS 0.06299f
C276 a_638_4130.n32 VSS 0.39246f
C277 a_638_4130.n33 VSS 0.06299f
C278 a_638_4130.n34 VSS 0.06299f
C279 a_638_4130.n35 VSS 0.06299f
C280 a_638_4130.n36 VSS 0.16485f
C281 a_638_4130.n37 VSS 0.06659f
C282 a_638_4130.n38 VSS 0.20049f
C283 a_638_4130.n39 VSS 0.87839f
C284 a_638_4130.t7 VSS 0.0123f
C285 a_638_4130.t11 VSS 0.0123f
C286 a_638_4130.n40 VSS 0.02602f
C287 a_638_4130.n41 VSS 0.09138f
C288 a_638_4130.t5 VSS 0.04286f
C289 a_638_4130.n42 VSS 0.20172f
C290 a_638_4130.t4 VSS 0.11442f
C291 a_638_4130.n43 VSS 0.07952f
C292 a_638_4130.t13 VSS 0.11442f
C293 a_638_4130.n44 VSS 0.06581f
C294 a_638_4130.t14 VSS 0.11442f
C295 a_638_4130.n45 VSS 0.06581f
C296 a_638_4130.t6 VSS 0.11442f
C297 a_638_4130.n46 VSS 0.04942f
C298 a_638_4130.t9 VSS 0.04286f
C299 a_638_4130.n47 VSS 0.20118f
C300 a_638_4130.t8 VSS 0.11442f
C301 a_638_4130.n48 VSS 0.07965f
C302 a_638_4130.t12 VSS 0.11442f
C303 a_638_4130.n49 VSS 0.06581f
C304 a_638_4130.t15 VSS 0.11442f
C305 a_638_4130.n50 VSS 0.06581f
C306 a_638_4130.t10 VSS 0.11442f
C307 a_638_4130.n51 VSS 0.04965f
C308 a_638_4130.n52 VSS 0.04124f
C309 a_638_4130.n53 VSS 0.03352f
C310 a_638_4130.n54 VSS 0.04849f
C311 a_638_4130.n55 VSS 0.04918f
C312 a_638_4130.n56 VSS 0.09849f
C313 a_638_4130.n57 VSS 0.38528f
C314 a_638_4130.n58 VSS 0.03393f
C315 a_638_4130.n59 VSS 0.06299f
C316 a_638_4130.n60 VSS 0.06299f
C317 a_638_4130.n61 VSS 0.06299f
C318 a_638_4130.n62 VSS 0.06803f
C319 a_638_4130.n63 VSS 0.17788f
C320 a_638_4130.n64 VSS 0.06299f
C321 a_638_4130.n65 VSS 0.06299f
C322 a_638_4130.n66 VSS 0.06299f
C323 a_638_4130.n67 VSS 0.11263f
C324 a_638_4130.n68 VSS 0.03344f
C325 a_638_4130.n69 VSS 0.48716f
C326 a_638_4130.n70 VSS 0.16713f
C327 a_638_4130.t3 VSS 0.08197f
C328 bias-network_0.IBIAS2.t13 VSS 0.05518f
C329 bias-network_0.IBIAS2.t9 VSS 0.05524f
C330 bias-network_0.IBIAS2.t8 VSS 0.12731f
C331 bias-network_0.IBIAS2.n0 VSS 0.18556f
C332 bias-network_0.IBIAS2.t17 VSS 0.12731f
C333 bias-network_0.IBIAS2.n1 VSS 0.08568f
C334 bias-network_0.IBIAS2.t18 VSS 0.12731f
C335 bias-network_0.IBIAS2.n2 VSS 0.08568f
C336 bias-network_0.IBIAS2.t10 VSS 0.12731f
C337 bias-network_0.IBIAS2.n3 VSS 0.06438f
C338 bias-network_0.IBIAS2.t11 VSS 0.01456f
C339 bias-network_0.IBIAS2.t15 VSS 0.01456f
C340 bias-network_0.IBIAS2.n4 VSS 0.02962f
C341 bias-network_0.IBIAS2.n5 VSS 0.17611f
C342 bias-network_0.IBIAS2.t14 VSS 0.12731f
C343 bias-network_0.IBIAS2.n6 VSS 0.06316f
C344 bias-network_0.IBIAS2.t19 VSS 0.12731f
C345 bias-network_0.IBIAS2.n7 VSS 0.08568f
C346 bias-network_0.IBIAS2.t16 VSS 0.12731f
C347 bias-network_0.IBIAS2.n8 VSS 0.08568f
C348 bias-network_0.IBIAS2.t12 VSS 0.12731f
C349 bias-network_0.IBIAS2.n9 VSS 0.07168f
C350 bias-network_0.IBIAS2.n10 VSS 0.2236f
C351 bias-network_0.IBIAS2.n11 VSS 2.34242f
C352 bias-network_0.IBIAS2.t3 VSS 0.02357f
C353 bias-network_0.IBIAS2.t1 VSS 0.02341f
C354 bias-network_0.IBIAS2.n12 VSS 0.30369f
C355 bias-network_0.IBIAS2.t2 VSS 0.02357f
C356 bias-network_0.IBIAS2.t0 VSS 0.02341f
C357 bias-network_0.IBIAS2.n13 VSS 0.45702f
C358 bias-network_0.IBIAS2.t7 VSS 0.00662f
C359 bias-network_0.IBIAS2.t5 VSS 0.00662f
C360 bias-network_0.IBIAS2.n14 VSS 0.01437f
C361 bias-network_0.IBIAS2.t6 VSS 0.00662f
C362 bias-network_0.IBIAS2.t4 VSS 0.00662f
C363 bias-network_0.IBIAS2.n15 VSS 0.01418f
C364 bias-network_0.IBIAS2.n16 VSS 0.29565f
C365 bias-network_0.IBIAS2.n17 VSS 0.40007f
C366 bias-network_0.IBIAS2.n18 VSS 0.29409f
C367 VDD.t0 VSS 0.00159f
C368 VDD.n0 VSS 0.35017f
C369 VDD.n1 VSS 2.02727f
C370 VDD.n2 VSS 0.4913f
C371 VDD.n3 VSS 0.48654f
C372 VDD.n4 VSS 0.98321f
C373 VDD.n5 VSS 0.05313f
C374 VDD.n6 VSS 1.98724f
C375 VDD.n7 VSS 0.36971f
C376 VDD.n8 VSS 0.46473f
C377 VDD.n9 VSS 0.92933f
C378 VDD.n10 VSS 0.97383f
C379 VDD.n11 VSS 1.02339f
C380 VDD.n12 VSS 0.51231f
C381 VDD.n13 VSS 0.29893f
C382 VDD.n14 VSS 0.26949f
C383 VDD.n15 VSS 0.02626f
C384 divider-feedback_0.VFB.t1 VSS 0.12764f
C385 divider-feedback_0.VFB.t0 VSS 0.57549f
C386 a_816_4748.t7 VSS 0.09686f
C387 a_816_4748.n0 VSS 0.05783f
C388 a_816_4748.n1 VSS 0.40486f
C389 a_816_4748.n2 VSS 0.07443f
C390 a_816_4748.t9 VSS 0.02283f
C391 a_816_4748.t10 VSS 0.02283f
C392 a_816_4748.n3 VSS 0.05161f
C393 a_816_4748.t11 VSS 0.02283f
C394 a_816_4748.t8 VSS 0.02283f
C395 a_816_4748.n4 VSS 0.05159f
C396 a_816_4748.n5 VSS 1.38869f
C397 a_816_4748.n6 VSS 0.07443f
C398 a_816_4748.n7 VSS 0.07443f
C399 a_816_4748.n8 VSS 0.07443f
C400 a_816_4748.n9 VSS 0.07443f
C401 a_816_4748.t1 VSS 0.09686f
C402 a_816_4748.t4 VSS 0.09686f
C403 a_816_4748.n10 VSS 0.19748f
C404 a_816_4748.n11 VSS 0.48422f
C405 a_816_4748.n12 VSS 0.05783f
C406 a_816_4748.n13 VSS 0.11934f
C407 a_816_4748.n14 VSS 0.29873f
C408 a_816_4748.n15 VSS 0.40473f
C409 a_816_4748.n16 VSS 0.07443f
C410 a_816_4748.n17 VSS 0.07443f
C411 a_816_4748.n18 VSS 0.23639f
C412 a_816_4748.n19 VSS 0.11085f
C413 a_816_4748.n20 VSS 0.19976f
C414 a_816_4748.n21 VSS 0.07443f
C415 a_816_4748.n22 VSS 0.07443f
C416 a_816_4748.n23 VSS 0.07443f
C417 a_816_4748.n24 VSS 0.07443f
C418 a_816_4748.t5 VSS 0.09686f
C419 a_816_4748.t2 VSS 0.09686f
C420 a_816_4748.n25 VSS 0.19748f
C421 a_816_4748.n26 VSS 0.48422f
C422 a_816_4748.n27 VSS 0.05783f
C423 a_816_4748.n28 VSS 0.11934f
C424 a_816_4748.n29 VSS 0.29873f
C425 a_816_4748.n30 VSS 0.40473f
C426 a_816_4748.n31 VSS 0.07443f
C427 a_816_4748.n32 VSS 0.07443f
C428 a_816_4748.n33 VSS 0.23639f
C429 a_816_4748.n34 VSS 0.11085f
C430 a_816_4748.n35 VSS 0.1151f
C431 a_816_4748.n36 VSS 0.2862f
C432 a_816_4748.n37 VSS 0.21256f
C433 a_816_4748.n38 VSS 0.07443f
C434 a_816_4748.n39 VSS 0.07443f
C435 a_816_4748.n40 VSS 0.07443f
C436 a_816_4748.n41 VSS 0.07443f
C437 a_816_4748.t6 VSS 0.09686f
C438 a_816_4748.t0 VSS 0.09686f
C439 a_816_4748.n42 VSS 0.19748f
C440 a_816_4748.n43 VSS 0.48422f
C441 a_816_4748.n44 VSS 0.05783f
C442 a_816_4748.n45 VSS 0.11934f
C443 a_816_4748.n46 VSS 0.29873f
C444 a_816_4748.n47 VSS 0.40473f
C445 a_816_4748.n48 VSS 0.07443f
C446 a_816_4748.n49 VSS 0.07443f
C447 a_816_4748.n50 VSS 0.23639f
C448 a_816_4748.n51 VSS 0.11085f
C449 a_816_4748.n52 VSS 0.19976f
C450 a_816_4748.n53 VSS 0.28882f
C451 a_816_4748.n54 VSS 0.1151f
C452 a_816_4748.n55 VSS 0.07443f
C453 a_816_4748.n56 VSS 0.07443f
C454 a_816_4748.n57 VSS 0.07443f
C455 a_816_4748.n58 VSS 0.11085f
C456 a_816_4748.n59 VSS 0.23639f
C457 a_816_4748.n60 VSS 0.07443f
C458 a_816_4748.n61 VSS 0.07443f
C459 a_816_4748.n62 VSS 0.11934f
C460 a_816_4748.n63 VSS 0.29867f
C461 a_816_4748.n64 VSS 0.48415f
C462 a_816_4748.n65 VSS 0.19748f
C463 a_816_4748.t3 VSS 0.09686f
C464 bias-network_0.VREF.t27 VSS 0.30538f
C465 bias-network_0.VREF.t17 VSS 0.30526f
C466 bias-network_0.VREF.n0 VSS 0.51813f
C467 bias-network_0.VREF.t18 VSS 0.30526f
C468 bias-network_0.VREF.n1 VSS 0.24774f
C469 bias-network_0.VREF.t24 VSS 0.30526f
C470 bias-network_0.VREF.n2 VSS 0.35627f
C471 bias-network_0.VREF.t23 VSS 0.30538f
C472 bias-network_0.VREF.t33 VSS 0.30526f
C473 bias-network_0.VREF.n3 VSS 0.51813f
C474 bias-network_0.VREF.t39 VSS 0.30526f
C475 bias-network_0.VREF.n4 VSS 0.24774f
C476 bias-network_0.VREF.t40 VSS 0.30526f
C477 bias-network_0.VREF.n5 VSS 0.35627f
C478 bias-network_0.VREF.n6 VSS 2.25468f
C479 bias-network_0.VREF.n7 VSS 1.55478f
C480 bias-network_0.VREF.t16 VSS 0.05942f
C481 bias-network_0.VREF.n8 VSS 0.15823f
C482 bias-network_0.VREF.t11 VSS 0.01613f
C483 bias-network_0.VREF.n9 VSS 0.03671f
C484 bias-network_0.VREF.t10 VSS 0.25115f
C485 bias-network_0.VREF.n10 VSS 0.0028f
C486 bias-network_0.VREF.n11 VSS 0.02164f
C487 bias-network_0.VREF.n12 VSS 0.11666f
C488 bias-network_0.VREF.n13 VSS 0.11655f
C489 bias-network_0.VREF.n14 VSS 0.11696f
C490 bias-network_0.VREF.n15 VSS 0.11625f
C491 bias-network_0.VREF.n16 VSS 0.11696f
C492 bias-network_0.VREF.t4 VSS 0.25115f
C493 bias-network_0.VREF.n17 VSS 0.0028f
C494 bias-network_0.VREF.t9 VSS 0.01613f
C495 bias-network_0.VREF.n18 VSS 0.03671f
C496 bias-network_0.VREF.n19 VSS 0.01911f
C497 bias-network_0.VREF.n20 VSS 0.01911f
C498 bias-network_0.VREF.n21 VSS 0.11666f
C499 bias-network_0.VREF.t8 VSS 0.25115f
C500 bias-network_0.VREF.n22 VSS 0.0028f
C501 bias-network_0.VREF.n23 VSS 0.11917f
C502 bias-network_0.VREF.t0 VSS 0.25115f
C503 bias-network_0.VREF.n24 VSS 0.0028f
C504 bias-network_0.VREF.n25 VSS 0.10562f
C505 bias-network_0.VREF.n26 VSS 0.01986f
C506 bias-network_0.VREF.t1 VSS 0.00459f
C507 bias-network_0.VREF.t13 VSS 0.00459f
C508 bias-network_0.VREF.n27 VSS 0.00972f
C509 bias-network_0.VREF.n28 VSS 0.02755f
C510 bias-network_0.VREF.n29 VSS 0.02169f
C511 bias-network_0.VREF.t12 VSS 0.25115f
C512 bias-network_0.VREF.n30 VSS 0.00225f
C513 bias-network_0.VREF.n31 VSS 0.10578f
C514 bias-network_0.VREF.n32 VSS 0.11573f
C515 bias-network_0.VREF.t5 VSS 0.01613f
C516 bias-network_0.VREF.n33 VSS 0.03712f
C517 bias-network_0.VREF.n34 VSS 0.01941f
C518 bias-network_0.VREF.n35 VSS 0.01941f
C519 bias-network_0.VREF.t7 VSS 0.01613f
C520 bias-network_0.VREF.n36 VSS 0.03712f
C521 bias-network_0.VREF.t6 VSS 0.25115f
C522 bias-network_0.VREF.n37 VSS 0.0028f
C523 bias-network_0.VREF.n38 VSS 0.20681f
C524 bias-network_0.VREF.t26 VSS 0.25115f
C525 bias-network_0.VREF.n39 VSS 0.18722f
C526 bias-network_0.VREF.t25 VSS 0.25115f
C527 bias-network_0.VREF.n40 VSS 0.23795f
C528 bias-network_0.VREF.t37 VSS 0.25115f
C529 bias-network_0.VREF.n41 VSS 0.23795f
C530 bias-network_0.VREF.t35 VSS 0.25115f
C531 bias-network_0.VREF.n42 VSS 0.23687f
C532 bias-network_0.VREF.n43 VSS 0.20237f
C533 bias-network_0.VREF.t32 VSS 0.25115f
C534 bias-network_0.VREF.n44 VSS 0.14848f
C535 bias-network_0.VREF.t34 VSS 0.25115f
C536 bias-network_0.VREF.n45 VSS 0.23795f
C537 bias-network_0.VREF.t21 VSS 0.25115f
C538 bias-network_0.VREF.n46 VSS 0.23795f
C539 bias-network_0.VREF.t22 VSS 0.25115f
C540 bias-network_0.VREF.n47 VSS 0.18722f
C541 bias-network_0.VREF.n48 VSS 0.19637f
C542 bias-network_0.VREF.t14 VSS 0.25115f
C543 bias-network_0.VREF.n49 VSS 0.0028f
C544 bias-network_0.VREF.n50 VSS 0.11625f
C545 bias-network_0.VREF.t3 VSS 0.00459f
C546 bias-network_0.VREF.t15 VSS 0.00459f
C547 bias-network_0.VREF.n51 VSS 0.00972f
C548 bias-network_0.VREF.n52 VSS 0.02755f
C549 bias-network_0.VREF.n53 VSS 0.01986f
C550 bias-network_0.VREF.n54 VSS 0.11655f
C551 bias-network_0.VREF.t2 VSS 0.25115f
C552 bias-network_0.VREF.n55 VSS 0.0028f
C553 bias-network_0.VREF.t30 VSS 0.25115f
C554 bias-network_0.VREF.n56 VSS 0.14848f
C555 bias-network_0.VREF.t31 VSS 0.25115f
C556 bias-network_0.VREF.n57 VSS 0.23795f
C557 bias-network_0.VREF.t19 VSS 0.25115f
C558 bias-network_0.VREF.n58 VSS 0.23795f
C559 bias-network_0.VREF.t20 VSS 0.25115f
C560 bias-network_0.VREF.n59 VSS 0.18722f
C561 bias-network_0.VREF.n60 VSS 0.19671f
C562 bias-network_0.VREF.n61 VSS 0.20654f
C563 bias-network_0.VREF.t29 VSS 0.25115f
C564 bias-network_0.VREF.n62 VSS 0.18722f
C565 bias-network_0.VREF.t28 VSS 0.25115f
C566 bias-network_0.VREF.n63 VSS 0.23795f
C567 bias-network_0.VREF.t38 VSS 0.25115f
C568 bias-network_0.VREF.n64 VSS 0.23795f
C569 bias-network_0.VREF.t36 VSS 0.25115f
C570 bias-network_0.VREF.n65 VSS 0.14848f
C571 bias-network_0.VREF.n66 VSS 0.16718f
C572 bias-network_0.VREF.n67 VSS 1.00082f
C573 a_3638_4130.n0 VSS 0.35061f
C574 a_3638_4130.n1 VSS 0.06349f
C575 a_3638_4130.n2 VSS 0.38914f
C576 a_3638_4130.n3 VSS 0.06245f
C577 a_3638_4130.n4 VSS 0.06245f
C578 a_3638_4130.n5 VSS 0.06245f
C579 a_3638_4130.n6 VSS 0.06245f
C580 a_3638_4130.n7 VSS 0.06245f
C581 a_3638_4130.n8 VSS 0.06245f
C582 a_3638_4130.n9 VSS 0.35099f
C583 a_3638_4130.n10 VSS 0.11166f
C584 a_3638_4130.t2 VSS 0.29843f
C585 a_3638_4130.n11 VSS 0.51272f
C586 a_3638_4130.n12 VSS 0.03315f
C587 a_3638_4130.n13 VSS 0.06245f
C588 a_3638_4130.n14 VSS 0.06245f
C589 a_3638_4130.n15 VSS 0.38915f
C590 a_3638_4130.n16 VSS 0.06245f
C591 a_3638_4130.n17 VSS 0.06245f
C592 a_3638_4130.n18 VSS 0.06245f
C593 a_3638_4130.n19 VSS 0.17635f
C594 a_3638_4130.n20 VSS 0.06745f
C595 a_3638_4130.n21 VSS 0.19877f
C596 a_3638_4130.n22 VSS 0.06245f
C597 a_3638_4130.n23 VSS 0.06245f
C598 a_3638_4130.n24 VSS 0.06245f
C599 a_3638_4130.n25 VSS 0.06245f
C600 a_3638_4130.n26 VSS 0.35099f
C601 a_3638_4130.n27 VSS 0.11166f
C602 a_3638_4130.t0 VSS 0.08127f
C603 a_3638_4130.t1 VSS 0.08127f
C604 a_3638_4130.n28 VSS 0.16569f
C605 a_3638_4130.n29 VSS 0.48293f
C606 a_3638_4130.n30 VSS 0.03315f
C607 a_3638_4130.n31 VSS 0.06245f
C608 a_3638_4130.n32 VSS 0.06245f
C609 a_3638_4130.n33 VSS 0.38915f
C610 a_3638_4130.n34 VSS 0.06245f
C611 a_3638_4130.n35 VSS 0.06245f
C612 a_3638_4130.n36 VSS 0.06245f
C613 a_3638_4130.n37 VSS 0.17635f
C614 a_3638_4130.n38 VSS 0.06745f
C615 a_3638_4130.n39 VSS 0.03364f
C616 a_3638_4130.n40 VSS 0.87081f
C617 a_3638_4130.t9 VSS 0.01219f
C618 a_3638_4130.t11 VSS 0.01219f
C619 a_3638_4130.n41 VSS 0.0258f
C620 a_3638_4130.n42 VSS 0.09059f
C621 a_3638_4130.t7 VSS 0.04249f
C622 a_3638_4130.n43 VSS 0.19998f
C623 a_3638_4130.t6 VSS 0.11343f
C624 a_3638_4130.n44 VSS 0.07883f
C625 a_3638_4130.t12 VSS 0.11343f
C626 a_3638_4130.n45 VSS 0.06525f
C627 a_3638_4130.t13 VSS 0.11343f
C628 a_3638_4130.n46 VSS 0.06525f
C629 a_3638_4130.t8 VSS 0.11343f
C630 a_3638_4130.n47 VSS 0.04899f
C631 a_3638_4130.t5 VSS 0.04249f
C632 a_3638_4130.n48 VSS 0.19944f
C633 a_3638_4130.t4 VSS 0.11343f
C634 a_3638_4130.n49 VSS 0.07896f
C635 a_3638_4130.t15 VSS 0.11343f
C636 a_3638_4130.n50 VSS 0.06525f
C637 a_3638_4130.t14 VSS 0.11343f
C638 a_3638_4130.n51 VSS 0.06525f
C639 a_3638_4130.t10 VSS 0.11343f
C640 a_3638_4130.n52 VSS 0.04922f
C641 a_3638_4130.n53 VSS 0.04088f
C642 a_3638_4130.n54 VSS 0.03323f
C643 a_3638_4130.n55 VSS 0.04807f
C644 a_3638_4130.n56 VSS 0.04875f
C645 a_3638_4130.n57 VSS 0.09764f
C646 a_3638_4130.n58 VSS 0.38195f
C647 a_3638_4130.n59 VSS 0.19877f
C648 a_3638_4130.n60 VSS 0.06245f
C649 a_3638_4130.n61 VSS 0.06245f
C650 a_3638_4130.n62 VSS 0.06245f
C651 a_3638_4130.n63 VSS 0.06602f
C652 a_3638_4130.n64 VSS 0.16343f
C653 a_3638_4130.n65 VSS 0.06349f
C654 a_3638_4130.n66 VSS 0.06245f
C655 a_3638_4130.n67 VSS 0.06245f
C656 a_3638_4130.n68 VSS 0.11169f
C657 a_3638_4130.n69 VSS 0.0337f
C658 a_3638_4130.n70 VSS 0.51679f
C659 a_3638_4130.t3 VSS 0.29843f
C660 a_3816_4748.t0 VSS 0.02888f
C661 a_3816_4748.n0 VSS 0.09417f
C662 a_3816_4748.n1 VSS 0.09417f
C663 a_3816_4748.n2 VSS 0.09417f
C664 a_3816_4748.n3 VSS 0.09417f
C665 a_3816_4748.t7 VSS 0.12254f
C666 a_3816_4748.t8 VSS 0.12254f
C667 a_3816_4748.n4 VSS 0.24984f
C668 a_3816_4748.n5 VSS 0.61261f
C669 a_3816_4748.n6 VSS 0.07316f
C670 a_3816_4748.n7 VSS 0.15098f
C671 a_3816_4748.n8 VSS 0.37794f
C672 a_3816_4748.n9 VSS 0.51205f
C673 a_3816_4748.n10 VSS 0.09417f
C674 a_3816_4748.n11 VSS 0.09417f
C675 a_3816_4748.n12 VSS 0.29907f
C676 a_3816_4748.n13 VSS 0.14024f
C677 a_3816_4748.n14 VSS 0.25272f
C678 a_3816_4748.n15 VSS 0.09417f
C679 a_3816_4748.n16 VSS 0.09417f
C680 a_3816_4748.n17 VSS 0.09417f
C681 a_3816_4748.n18 VSS 0.09417f
C682 a_3816_4748.t9 VSS 0.12254f
C683 a_3816_4748.t4 VSS 0.12254f
C684 a_3816_4748.n19 VSS 0.24984f
C685 a_3816_4748.n20 VSS 0.61261f
C686 a_3816_4748.n21 VSS 0.07316f
C687 a_3816_4748.n22 VSS 0.15098f
C688 a_3816_4748.n23 VSS 0.37794f
C689 a_3816_4748.n24 VSS 0.51205f
C690 a_3816_4748.n25 VSS 0.09417f
C691 a_3816_4748.n26 VSS 0.09417f
C692 a_3816_4748.n27 VSS 0.29907f
C693 a_3816_4748.n28 VSS 0.14024f
C694 a_3816_4748.n29 VSS 0.14562f
C695 a_3816_4748.n30 VSS 0.3654f
C696 a_3816_4748.n31 VSS 0.09417f
C697 a_3816_4748.n32 VSS 0.09417f
C698 a_3816_4748.n33 VSS 0.09417f
C699 a_3816_4748.n34 VSS 0.09417f
C700 a_3816_4748.t11 VSS 0.12254f
C701 a_3816_4748.t6 VSS 0.12254f
C702 a_3816_4748.n35 VSS 0.24984f
C703 a_3816_4748.n36 VSS 0.61261f
C704 a_3816_4748.n37 VSS 0.07316f
C705 a_3816_4748.n38 VSS 0.15098f
C706 a_3816_4748.n39 VSS 0.37794f
C707 a_3816_4748.n40 VSS 0.51205f
C708 a_3816_4748.n41 VSS 0.09417f
C709 a_3816_4748.n42 VSS 0.09417f
C710 a_3816_4748.n43 VSS 0.29907f
C711 a_3816_4748.n44 VSS 0.14024f
C712 a_3816_4748.n45 VSS 0.25272f
C713 a_3816_4748.n46 VSS 0.09417f
C714 a_3816_4748.n47 VSS 0.09417f
C715 a_3816_4748.n48 VSS 0.09417f
C716 a_3816_4748.n49 VSS 0.09417f
C717 a_3816_4748.t5 VSS 0.12254f
C718 a_3816_4748.t10 VSS 0.12254f
C719 a_3816_4748.n50 VSS 0.24984f
C720 a_3816_4748.n51 VSS 0.61261f
C721 a_3816_4748.n52 VSS 0.07316f
C722 a_3816_4748.n53 VSS 0.15098f
C723 a_3816_4748.n54 VSS 0.37794f
C724 a_3816_4748.n55 VSS 0.51205f
C725 a_3816_4748.n56 VSS 0.09417f
C726 a_3816_4748.n57 VSS 0.09417f
C727 a_3816_4748.n58 VSS 0.29907f
C728 a_3816_4748.n59 VSS 0.14024f
C729 a_3816_4748.n60 VSS 0.14562f
C730 a_3816_4748.n61 VSS 0.36208f
C731 a_3816_4748.n62 VSS 0.26892f
C732 a_3816_4748.t2 VSS 0.02888f
C733 a_3816_4748.t1 VSS 0.02888f
C734 a_3816_4748.n63 VSS 0.06527f
C735 a_3816_4748.n64 VSS 1.75691f
C736 a_3816_4748.n65 VSS 0.06529f
C737 a_3816_4748.t3 VSS 0.02888f
C738 bias-network_0.IBIAS1.t28 VSS 0.45667f
C739 bias-network_0.IBIAS1.t34 VSS 0.4561f
C740 bias-network_0.IBIAS1.n0 VSS 0.77559f
C741 bias-network_0.IBIAS1.t33 VSS 0.4561f
C742 bias-network_0.IBIAS1.n1 VSS 0.36997f
C743 bias-network_0.IBIAS1.t30 VSS 0.4561f
C744 bias-network_0.IBIAS1.n2 VSS 0.44551f
C745 bias-network_0.IBIAS1.n3 VSS 0.17705f
C746 bias-network_0.IBIAS1.t8 VSS 6.66341f
C747 bias-network_0.IBIAS1.t9 VSS 6.09144f
C748 bias-network_0.IBIAS1.n4 VSS 1.07089f
C749 bias-network_0.IBIAS1.t10 VSS 6.09144f
C750 bias-network_0.IBIAS1.n5 VSS 0.82143f
C751 bias-network_0.IBIAS1.t11 VSS 6.09144f
C752 bias-network_0.IBIAS1.n6 VSS 2.13254f
C753 bias-network_0.IBIAS1.n7 VSS 0.87946f
C754 bias-network_0.IBIAS1.n8 VSS 0.3192f
C755 bias-network_0.IBIAS1.t1 VSS 0.05713f
C756 bias-network_0.IBIAS1.t3 VSS 0.05719f
C757 bias-network_0.IBIAS1.t2 VSS 0.1318f
C758 bias-network_0.IBIAS1.n9 VSS 0.19211f
C759 bias-network_0.IBIAS1.t35 VSS 0.1318f
C760 bias-network_0.IBIAS1.n10 VSS 0.0887f
C761 bias-network_0.IBIAS1.t29 VSS 0.1318f
C762 bias-network_0.IBIAS1.n11 VSS 0.0887f
C763 bias-network_0.IBIAS1.t4 VSS 0.1318f
C764 bias-network_0.IBIAS1.n12 VSS 0.06665f
C765 bias-network_0.IBIAS1.t5 VSS 0.01507f
C766 bias-network_0.IBIAS1.t7 VSS 0.01507f
C767 bias-network_0.IBIAS1.n13 VSS 0.03066f
C768 bias-network_0.IBIAS1.n14 VSS 0.18232f
C769 bias-network_0.IBIAS1.t6 VSS 0.1318f
C770 bias-network_0.IBIAS1.n15 VSS 0.06539f
C771 bias-network_0.IBIAS1.t31 VSS 0.1318f
C772 bias-network_0.IBIAS1.n16 VSS 0.0887f
C773 bias-network_0.IBIAS1.t32 VSS 0.1318f
C774 bias-network_0.IBIAS1.n17 VSS 0.0887f
C775 bias-network_0.IBIAS1.t0 VSS 0.1318f
C776 bias-network_0.IBIAS1.n18 VSS 0.07421f
C777 bias-network_0.IBIAS1.n19 VSS 0.23149f
C778 bias-network_0.IBIAS1.n20 VSS 0.8212f
C779 bias-network_0.IBIAS1.t26 VSS 0.02441f
C780 bias-network_0.IBIAS1.t27 VSS 0.02425f
C781 bias-network_0.IBIAS1.n21 VSS 0.47412f
C782 bias-network_0.IBIAS1.t18 VSS 0.00685f
C783 bias-network_0.IBIAS1.t20 VSS 0.00685f
C784 bias-network_0.IBIAS1.n22 VSS 0.01489f
C785 bias-network_0.IBIAS1.t19 VSS 0.00685f
C786 bias-network_0.IBIAS1.t21 VSS 0.00685f
C787 bias-network_0.IBIAS1.n23 VSS 0.01469f
C788 bias-network_0.IBIAS1.n24 VSS 0.30718f
C789 bias-network_0.IBIAS1.n25 VSS 0.41208f
C790 bias-network_0.IBIAS1.t23 VSS 0.02441f
C791 bias-network_0.IBIAS1.t24 VSS 0.02425f
C792 bias-network_0.IBIAS1.n26 VSS 0.31551f
C793 bias-network_0.IBIAS1.n27 VSS 0.27542f
C794 bias-network_0.IBIAS1.n28 VSS 0.20706f
C795 bias-network_0.IBIAS1.n29 VSS 1.18295f
C796 bias-network_0.IBIAS1.t17 VSS 0.06395f
C797 bias-network_0.IBIAS1.t22 VSS 0.06395f
C798 bias-network_0.IBIAS1.n30 VSS 0.16662f
C799 bias-network_0.IBIAS1.t15 VSS 0.00959f
C800 bias-network_0.IBIAS1.t12 VSS 0.00959f
C801 bias-network_0.IBIAS1.n31 VSS 0.02444f
C802 bias-network_0.IBIAS1.n32 VSS 1.35919f
C803 bias-network_0.IBIAS1.t25 VSS 0.06395f
C804 bias-network_0.IBIAS1.t16 VSS 0.06395f
C805 bias-network_0.IBIAS1.n33 VSS 0.16662f
C806 bias-network_0.IBIAS1.t13 VSS 0.00959f
C807 bias-network_0.IBIAS1.t14 VSS 0.00959f
C808 bias-network_0.IBIAS1.n34 VSS 0.02444f
C809 bias-network_0.IBIAS1.n35 VSS 1.61591f
C810 bias-network_0.IBIAS1.n36 VSS 0.14017f
C811 bias-network_0.IBIAS1.n37 VSS 0.0126f
C812 OUT.t1032 VSS 7.69893f
C813 OUT.t1025 VSS 3.91234f
C814 OUT.n0 VSS 6.9506f
C815 OUT.t1026 VSS 3.91234f
C816 OUT.n1 VSS 5.3686f
C817 OUT.t1029 VSS 3.91234f
C818 OUT.n2 VSS 5.73967f
C819 OUT.t1027 VSS 7.69893f
C820 OUT.t1028 VSS 3.91234f
C821 OUT.n3 VSS 6.9506f
C822 OUT.t1030 VSS 3.91234f
C823 OUT.n4 VSS 5.3686f
C824 OUT.t1031 VSS 3.91234f
C825 OUT.n5 VSS 5.73967f
C826 OUT.n6 VSS 0.38145f
C827 OUT.n8 VSS 0.38145f
C828 OUT.n10 VSS 0.57218f
C829 OUT.n11 VSS 0.1981f
C830 OUT.n12 VSS 0.11302f
C831 OUT.n13 VSS 0.55099f
C832 OUT.n14 VSS 0.16954f
C833 OUT.n15 VSS 0.16736f
C834 OUT.n16 VSS 0.22387f
C835 OUT.t535 VSS 0.01473f
C836 OUT.t74 VSS 0.01481f
C837 OUT.n17 VSS 0.33133f
C838 OUT.t815 VSS 0.01455f
C839 OUT.n18 VSS 0.03307f
C840 OUT.t793 VSS 0.01455f
C841 OUT.n19 VSS 0.0323f
C842 OUT.n20 VSS 0.11411f
C843 OUT.n21 VSS 0.11411f
C844 OUT.t764 VSS 0.01455f
C845 OUT.n22 VSS 0.03251f
C846 OUT.t638 VSS 0.01455f
C847 OUT.n23 VSS 0.03329f
C848 OUT.n24 VSS 0.11683f
C849 OUT.n25 VSS 0.11683f
C850 OUT.t610 VSS 0.01455f
C851 OUT.n26 VSS 0.03381f
C852 OUT.t328 VSS 0.01455f
C853 OUT.n27 VSS 0.03251f
C854 OUT.n28 VSS 0.11411f
C855 OUT.n29 VSS 0.11411f
C856 OUT.t302 VSS 0.01455f
C857 OUT.n30 VSS 0.03251f
C858 OUT.t635 VSS 0.01455f
C859 OUT.n31 VSS 0.03251f
C860 OUT.n32 VSS 0.11683f
C861 OUT.n33 VSS 0.11683f
C862 OUT.t492 VSS 0.01455f
C863 OUT.n34 VSS 0.03434f
C864 OUT.t469 VSS 0.01455f
C865 OUT.n35 VSS 0.03251f
C866 OUT.n36 VSS 0.11411f
C867 OUT.n37 VSS 0.11411f
C868 OUT.t195 VSS 0.01455f
C869 OUT.n38 VSS 0.03329f
C870 OUT.t165 VSS 0.01455f
C871 OUT.n39 VSS 0.03251f
C872 OUT.n40 VSS 0.11411f
C873 OUT.n41 VSS 0.11411f
C874 OUT.t139 VSS 0.01455f
C875 OUT.n42 VSS 0.03242f
C876 OUT.t202 VSS 0.01455f
C877 OUT.n43 VSS 0.0332f
C878 OUT.n44 VSS 0.11683f
C879 OUT.n45 VSS 0.11683f
C880 OUT.t174 VSS 0.01455f
C881 OUT.n46 VSS 0.03371f
C882 OUT.t242 VSS 0.01455f
C883 OUT.n47 VSS 0.03242f
C884 OUT.n48 VSS 0.11411f
C885 OUT.n49 VSS 0.11411f
C886 OUT.t222 VSS 0.01455f
C887 OUT.n50 VSS 0.03217f
C888 OUT.t75 VSS 0.01455f
C889 OUT.n51 VSS 0.03242f
C890 OUT.n52 VSS 0.11683f
C891 OUT.n53 VSS 0.11683f
C892 OUT.t54 VSS 0.01455f
C893 OUT.n54 VSS 0.03425f
C894 OUT.t24 VSS 0.01455f
C895 OUT.n55 VSS 0.03243f
C896 OUT.n56 VSS 0.11411f
C897 OUT.n57 VSS 0.11411f
C898 OUT.t761 VSS 0.01455f
C899 OUT.n58 VSS 0.03319f
C900 OUT.t736 VSS 0.01455f
C901 OUT.n59 VSS 0.03217f
C902 OUT.n60 VSS 0.11411f
C903 OUT.n61 VSS 0.11411f
C904 OUT.t611 VSS 0.01455f
C905 OUT.n62 VSS 0.03242f
C906 OUT.t585 VSS 0.01455f
C907 OUT.n63 VSS 0.0332f
C908 OUT.n64 VSS 0.11683f
C909 OUT.n65 VSS 0.11683f
C910 OUT.t902 VSS 0.01455f
C911 OUT.n66 VSS 0.03371f
C912 OUT.t632 VSS 0.01455f
C913 OUT.n67 VSS 0.03242f
C914 OUT.n68 VSS 0.11411f
C915 OUT.n69 VSS 0.11411f
C916 OUT.t606 VSS 0.01455f
C917 OUT.n70 VSS 0.03217f
C918 OUT.t468 VSS 0.01455f
C919 OUT.n71 VSS 0.03242f
C920 OUT.n72 VSS 0.11411f
C921 OUT.n73 VSS 0.11411f
C922 OUT.t444 VSS 0.01455f
C923 OUT.n74 VSS 0.03243f
C924 OUT.t420 VSS 0.01455f
C925 OUT.n75 VSS 0.03372f
C926 OUT.n76 VSS 0.11683f
C927 OUT.n77 VSS 0.11683f
C928 OUT.t137 VSS 0.01455f
C929 OUT.n78 VSS 0.03319f
C930 OUT.t109 VSS 0.01455f
C931 OUT.n79 VSS 0.03217f
C932 OUT.n80 VSS 0.11411f
C933 OUT.n81 VSS 0.11411f
C934 OUT.t315 VSS 0.01455f
C935 OUT.n82 VSS 0.03242f
C936 OUT.t293 VSS 0.01455f
C937 OUT.n83 VSS 0.0332f
C938 OUT.n84 VSS 0.11683f
C939 OUT.n85 VSS 0.11683f
C940 OUT.t274 VSS 0.01455f
C941 OUT.n86 VSS 0.03371f
C942 OUT.t1014 VSS 0.01455f
C943 OUT.n87 VSS 0.03242f
C944 OUT.n88 VSS 0.11411f
C945 OUT.n89 VSS 0.11411f
C946 OUT.t869 VSS 0.01455f
C947 OUT.n90 VSS 0.03217f
C948 OUT.t843 VSS 0.01455f
C949 OUT.n91 VSS 0.03242f
C950 OUT.n92 VSS 0.11411f
C951 OUT.n93 VSS 0.11411f
C952 OUT.t821 VSS 0.01455f
C953 OUT.n94 VSS 0.03243f
C954 OUT.t796 VSS 0.01455f
C955 OUT.n95 VSS 0.03372f
C956 OUT.n96 VSS 0.11411f
C957 OUT.n97 VSS 0.11411f
C958 OUT.t859 VSS 0.01455f
C959 OUT.n98 VSS 0.03244f
C960 OUT.t716 VSS 0.01455f
C961 OUT.n99 VSS 0.03478f
C962 OUT.n100 VSS 0.11683f
C963 OUT.n101 VSS 0.11683f
C964 OUT.t698 VSS 0.01455f
C965 OUT.n102 VSS 0.03242f
C966 OUT.t680 VSS 0.01455f
C967 OUT.n103 VSS 0.0332f
C968 OUT.n104 VSS 0.11411f
C969 OUT.n105 VSS 0.11411f
C970 OUT.t663 VSS 0.01455f
C971 OUT.n106 VSS 0.03244f
C972 OUT.t378 VSS 0.01455f
C973 OUT.n107 VSS 0.03426f
C974 OUT.n108 VSS 0.11683f
C975 OUT.n109 VSS 0.11683f
C976 OUT.t243 VSS 0.01455f
C977 OUT.n110 VSS 0.03217f
C978 OUT.t220 VSS 0.01455f
C979 OUT.n111 VSS 0.03242f
C980 OUT.n112 VSS 0.11411f
C981 OUT.n113 VSS 0.11411f
C982 OUT.t197 VSS 0.01455f
C983 OUT.n114 VSS 0.03243f
C984 OUT.t518 VSS 0.01455f
C985 OUT.n115 VSS 0.03372f
C986 OUT.n116 VSS 0.11411f
C987 OUT.n117 VSS 0.11411f
C988 OUT.t114 VSS 0.01455f
C989 OUT.n118 VSS 0.03244f
C990 OUT.t90 VSS 0.01455f
C991 OUT.n119 VSS 0.03478f
C992 OUT.n120 VSS 0.11683f
C993 OUT.n121 VSS 0.11683f
C994 OUT.t66 VSS 0.01455f
C995 OUT.n122 VSS 0.03242f
C996 OUT.t41 VSS 0.01455f
C997 OUT.n123 VSS 0.0332f
C998 OUT.n124 VSS 0.11683f
C999 OUT.n125 VSS 0.11683f
C1000 OUT.t17 VSS 0.01455f
C1001 OUT.n126 VSS 0.03371f
C1002 OUT.t574 VSS 0.01455f
C1003 OUT.n127 VSS 0.03242f
C1004 OUT.n128 VSS 0.11411f
C1005 OUT.n129 VSS 0.11411f
C1006 OUT.t551 VSS 0.01455f
C1007 OUT.n130 VSS 0.03217f
C1008 OUT.t861 VSS 0.01455f
C1009 OUT.n131 VSS 0.03242f
C1010 OUT.n132 VSS 0.11411f
C1011 OUT.n133 VSS 0.11411f
C1012 OUT.t837 VSS 0.01455f
C1013 OUT.n134 VSS 0.03243f
C1014 OUT.t449 VSS 0.01455f
C1015 OUT.n135 VSS 0.03372f
C1016 OUT.n136 VSS 0.11683f
C1017 OUT.n137 VSS 0.11683f
C1018 OUT.t488 VSS 0.01455f
C1019 OUT.n138 VSS 0.03319f
C1020 OUT.t511 VSS 0.01455f
C1021 OUT.n139 VSS 0.03217f
C1022 OUT.n140 VSS 0.12616f
C1023 OUT.n141 VSS 0.19338f
C1024 OUT.n142 VSS 0.13041f
C1025 OUT.n143 VSS 0.26082f
C1026 OUT.t800 VSS 0.01473f
C1027 OUT.t357 VSS 0.01481f
C1028 OUT.n144 VSS 0.33121f
C1029 OUT.t73 VSS 0.01455f
C1030 OUT.n145 VSS 0.03307f
C1031 OUT.t51 VSS 0.01455f
C1032 OUT.n146 VSS 0.0323f
C1033 OUT.n147 VSS 0.11411f
C1034 OUT.n148 VSS 0.11411f
C1035 OUT.t22 VSS 0.01455f
C1036 OUT.n149 VSS 0.03251f
C1037 OUT.t905 VSS 0.01455f
C1038 OUT.n150 VSS 0.03198f
C1039 OUT.n151 VSS 0.11683f
C1040 OUT.n152 VSS 0.11683f
C1041 OUT.t881 VSS 0.01455f
C1042 OUT.n153 VSS 0.03145f
C1043 OUT.t609 VSS 0.01455f
C1044 OUT.n154 VSS 0.03251f
C1045 OUT.n155 VSS 0.11411f
C1046 OUT.n156 VSS 0.11411f
C1047 OUT.t584 VSS 0.01455f
C1048 OUT.n157 VSS 0.03251f
C1049 OUT.t900 VSS 0.01455f
C1050 OUT.n158 VSS 0.03251f
C1051 OUT.n159 VSS 0.11683f
C1052 OUT.n160 VSS 0.11683f
C1053 OUT.t757 VSS 0.01455f
C1054 OUT.n161 VSS 0.03092f
C1055 OUT.t732 VSS 0.01455f
C1056 OUT.n162 VSS 0.03251f
C1057 OUT.n163 VSS 0.11411f
C1058 OUT.n164 VSS 0.11411f
C1059 OUT.t467 VSS 0.01455f
C1060 OUT.n165 VSS 0.03198f
C1061 OUT.t443 VSS 0.01455f
C1062 OUT.n166 VSS 0.03251f
C1063 OUT.n167 VSS 0.11411f
C1064 OUT.n168 VSS 0.11411f
C1065 OUT.t418 VSS 0.01455f
C1066 OUT.n169 VSS 0.0323f
C1067 OUT.t478 VSS 0.01455f
C1068 OUT.n170 VSS 0.03176f
C1069 OUT.n171 VSS 0.11683f
C1070 OUT.n172 VSS 0.11683f
C1071 OUT.t452 VSS 0.01455f
C1072 OUT.n173 VSS 0.03124f
C1073 OUT.t524 VSS 0.01455f
C1074 OUT.n174 VSS 0.0323f
C1075 OUT.n175 VSS 0.11411f
C1076 OUT.n176 VSS 0.11411f
C1077 OUT.t500 VSS 0.01455f
C1078 OUT.n177 VSS 0.0323f
C1079 OUT.t355 VSS 0.01455f
C1080 OUT.n178 VSS 0.0323f
C1081 OUT.n179 VSS 0.11683f
C1082 OUT.n180 VSS 0.11683f
C1083 OUT.t330 VSS 0.01455f
C1084 OUT.n181 VSS 0.0307f
C1085 OUT.t303 VSS 0.01455f
C1086 OUT.n182 VSS 0.0323f
C1087 OUT.n183 VSS 0.11411f
C1088 OUT.n184 VSS 0.11411f
C1089 OUT.t23 VSS 0.01455f
C1090 OUT.n185 VSS 0.03177f
C1091 OUT.t1022 VSS 0.01455f
C1092 OUT.n186 VSS 0.0323f
C1093 OUT.n187 VSS 0.11411f
C1094 OUT.n188 VSS 0.11411f
C1095 OUT.t880 VSS 0.01455f
C1096 OUT.n189 VSS 0.0323f
C1097 OUT.t854 VSS 0.01455f
C1098 OUT.n190 VSS 0.03176f
C1099 OUT.n191 VSS 0.11683f
C1100 OUT.n192 VSS 0.11683f
C1101 OUT.t167 VSS 0.01455f
C1102 OUT.n193 VSS 0.03124f
C1103 OUT.t899 VSS 0.01455f
C1104 OUT.n194 VSS 0.0323f
C1105 OUT.n195 VSS 0.11411f
C1106 OUT.n196 VSS 0.11411f
C1107 OUT.t877 VSS 0.01455f
C1108 OUT.n197 VSS 0.0323f
C1109 OUT.t733 VSS 0.01455f
C1110 OUT.n198 VSS 0.0323f
C1111 OUT.n199 VSS 0.11411f
C1112 OUT.n200 VSS 0.11411f
C1113 OUT.t711 VSS 0.01455f
C1114 OUT.n201 VSS 0.0323f
C1115 OUT.t689 VSS 0.01455f
C1116 OUT.n202 VSS 0.03123f
C1117 OUT.n203 VSS 0.11683f
C1118 OUT.n204 VSS 0.11683f
C1119 OUT.t414 VSS 0.01455f
C1120 OUT.n205 VSS 0.03177f
C1121 OUT.t387 VSS 0.01455f
C1122 OUT.n206 VSS 0.0323f
C1123 OUT.n207 VSS 0.11411f
C1124 OUT.n208 VSS 0.11411f
C1125 OUT.t600 VSS 0.01455f
C1126 OUT.n209 VSS 0.0323f
C1127 OUT.t577 VSS 0.01455f
C1128 OUT.n210 VSS 0.03176f
C1129 OUT.n211 VSS 0.11683f
C1130 OUT.n212 VSS 0.11683f
C1131 OUT.t552 VSS 0.01455f
C1132 OUT.n213 VSS 0.03124f
C1133 OUT.t270 VSS 0.01455f
C1134 OUT.n214 VSS 0.0323f
C1135 OUT.n215 VSS 0.11411f
C1136 OUT.n216 VSS 0.11411f
C1137 OUT.t128 VSS 0.01455f
C1138 OUT.n217 VSS 0.0323f
C1139 OUT.t104 VSS 0.01455f
C1140 OUT.n218 VSS 0.0323f
C1141 OUT.n219 VSS 0.11411f
C1142 OUT.n220 VSS 0.11411f
C1143 OUT.t77 VSS 0.01455f
C1144 OUT.n221 VSS 0.0323f
C1145 OUT.t57 VSS 0.01455f
C1146 OUT.n222 VSS 0.03123f
C1147 OUT.n223 VSS 0.11411f
C1148 OUT.n224 VSS 0.11411f
C1149 OUT.t121 VSS 0.01455f
C1150 OUT.n225 VSS 0.0323f
C1151 OUT.t1002 VSS 0.01455f
C1152 OUT.n226 VSS 0.03017f
C1153 OUT.n227 VSS 0.11683f
C1154 OUT.n228 VSS 0.11683f
C1155 OUT.t978 VSS 0.01455f
C1156 OUT.n229 VSS 0.0323f
C1157 OUT.t957 VSS 0.01455f
C1158 OUT.n230 VSS 0.03176f
C1159 OUT.n231 VSS 0.11411f
C1160 OUT.n232 VSS 0.11411f
C1161 OUT.t935 VSS 0.01455f
C1162 OUT.n233 VSS 0.0323f
C1163 OUT.t661 VSS 0.01455f
C1164 OUT.n234 VSS 0.0307f
C1165 OUT.n235 VSS 0.11683f
C1166 OUT.n236 VSS 0.11683f
C1167 OUT.t523 VSS 0.01455f
C1168 OUT.n237 VSS 0.0323f
C1169 OUT.t498 VSS 0.01455f
C1170 OUT.n238 VSS 0.0323f
C1171 OUT.n239 VSS 0.11411f
C1172 OUT.n240 VSS 0.11411f
C1173 OUT.t472 VSS 0.01455f
C1174 OUT.n241 VSS 0.0323f
C1175 OUT.t785 VSS 0.01455f
C1176 OUT.n242 VSS 0.03123f
C1177 OUT.n243 VSS 0.11411f
C1178 OUT.n244 VSS 0.11411f
C1179 OUT.t392 VSS 0.01455f
C1180 OUT.n245 VSS 0.0323f
C1181 OUT.t368 VSS 0.01455f
C1182 OUT.n246 VSS 0.03017f
C1183 OUT.n247 VSS 0.11683f
C1184 OUT.n248 VSS 0.11683f
C1185 OUT.t346 VSS 0.01455f
C1186 OUT.n249 VSS 0.0323f
C1187 OUT.t321 VSS 0.01455f
C1188 OUT.n250 VSS 0.03176f
C1189 OUT.n251 VSS 0.11683f
C1190 OUT.n252 VSS 0.11683f
C1191 OUT.t300 VSS 0.01455f
C1192 OUT.n253 VSS 0.03124f
C1193 OUT.t840 VSS 0.01455f
C1194 OUT.n254 VSS 0.0323f
C1195 OUT.n255 VSS 0.11411f
C1196 OUT.n256 VSS 0.11411f
C1197 OUT.t819 VSS 0.01455f
C1198 OUT.n257 VSS 0.0323f
C1199 OUT.t123 VSS 0.01455f
C1200 OUT.n258 VSS 0.0323f
C1201 OUT.n259 VSS 0.11411f
C1202 OUT.n260 VSS 0.11411f
C1203 OUT.t100 VSS 0.01455f
C1204 OUT.n261 VSS 0.0323f
C1205 OUT.t713 VSS 0.01455f
C1206 OUT.n262 VSS 0.03123f
C1207 OUT.n263 VSS 0.11683f
C1208 OUT.n264 VSS 0.11683f
C1209 OUT.t752 VSS 0.01455f
C1210 OUT.n265 VSS 0.03177f
C1211 OUT.t776 VSS 0.01455f
C1212 OUT.n266 VSS 0.0323f
C1213 OUT.n267 VSS 0.12616f
C1214 OUT.n268 VSS 0.19326f
C1215 OUT.n269 VSS 0.13041f
C1216 OUT.n270 VSS 0.55099f
C1217 OUT.n271 VSS 0.15867f
C1218 OUT.t306 VSS 0.01473f
C1219 OUT.t876 VSS 0.01481f
C1220 OUT.n272 VSS 0.33127f
C1221 OUT.t603 VSS 0.01455f
C1222 OUT.n273 VSS 0.03355f
C1223 OUT.t581 VSS 0.01455f
C1224 OUT.n274 VSS 0.0318f
C1225 OUT.n275 VSS 0.11411f
C1226 OUT.n276 VSS 0.11411f
C1227 OUT.t556 VSS 0.01455f
C1228 OUT.n277 VSS 0.03304f
C1229 OUT.t413 VSS 0.01455f
C1230 OUT.n278 VSS 0.03356f
C1231 OUT.n279 VSS 0.11683f
C1232 OUT.n280 VSS 0.11683f
C1233 OUT.t386 VSS 0.01455f
C1234 OUT.n281 VSS 0.0343f
C1235 OUT.t106 VSS 0.01455f
C1236 OUT.n282 VSS 0.03303f
C1237 OUT.n283 VSS 0.11411f
C1238 OUT.n284 VSS 0.11411f
C1239 OUT.t80 VSS 0.01455f
C1240 OUT.n285 VSS 0.03302f
C1241 OUT.t406 VSS 0.01455f
C1242 OUT.n286 VSS 0.03303f
C1243 OUT.n287 VSS 0.11683f
C1244 OUT.n288 VSS 0.11683f
C1245 OUT.t266 VSS 0.01455f
C1246 OUT.n289 VSS 0.03483f
C1247 OUT.t247 VSS 0.01455f
C1248 OUT.n290 VSS 0.03305f
C1249 OUT.n291 VSS 0.11411f
C1250 OUT.n292 VSS 0.11411f
C1251 OUT.t982 VSS 0.01455f
C1252 OUT.n293 VSS 0.03376f
C1253 OUT.t960 VSS 0.01455f
C1254 OUT.n294 VSS 0.03201f
C1255 OUT.n295 VSS 0.11411f
C1256 OUT.n296 VSS 0.11411f
C1257 OUT.t938 VSS 0.01455f
C1258 OUT.n297 VSS 0.03282f
C1259 OUT.t998 VSS 0.01455f
C1260 OUT.n298 VSS 0.03335f
C1261 OUT.n299 VSS 0.11683f
C1262 OUT.n300 VSS 0.11683f
C1263 OUT.t968 VSS 0.01455f
C1264 OUT.n301 VSS 0.03408f
C1265 OUT.t15 VSS 0.01455f
C1266 OUT.n302 VSS 0.03282f
C1267 OUT.n303 VSS 0.11411f
C1268 OUT.n304 VSS 0.11411f
C1269 OUT.t1018 VSS 0.01455f
C1270 OUT.n305 VSS 0.0328f
C1271 OUT.t875 VSS 0.01455f
C1272 OUT.n306 VSS 0.03282f
C1273 OUT.n307 VSS 0.11683f
C1274 OUT.n308 VSS 0.11683f
C1275 OUT.t847 VSS 0.01455f
C1276 OUT.n309 VSS 0.03462f
C1277 OUT.t822 VSS 0.01455f
C1278 OUT.n310 VSS 0.03284f
C1279 OUT.n311 VSS 0.11411f
C1280 OUT.n312 VSS 0.11411f
C1281 OUT.t557 VSS 0.01455f
C1282 OUT.n313 VSS 0.03355f
C1283 OUT.t529 VSS 0.01455f
C1284 OUT.n314 VSS 0.0318f
C1285 OUT.n315 VSS 0.11411f
C1286 OUT.n316 VSS 0.11411f
C1287 OUT.t385 VSS 0.01455f
C1288 OUT.n317 VSS 0.03282f
C1289 OUT.t361 VSS 0.01455f
C1290 OUT.n318 VSS 0.03335f
C1291 OUT.n319 VSS 0.11683f
C1292 OUT.n320 VSS 0.11683f
C1293 OUT.t685 VSS 0.01455f
C1294 OUT.n321 VSS 0.03408f
C1295 OUT.t403 VSS 0.01455f
C1296 OUT.n322 VSS 0.03282f
C1297 OUT.n323 VSS 0.11411f
C1298 OUT.n324 VSS 0.11411f
C1299 OUT.t381 VSS 0.01455f
C1300 OUT.n325 VSS 0.0328f
C1301 OUT.t248 VSS 0.01455f
C1302 OUT.n326 VSS 0.03282f
C1303 OUT.n327 VSS 0.11411f
C1304 OUT.n328 VSS 0.11411f
C1305 OUT.t225 VSS 0.01455f
C1306 OUT.n329 VSS 0.03285f
C1307 OUT.t201 VSS 0.01455f
C1308 OUT.n330 VSS 0.03388f
C1309 OUT.n331 VSS 0.11683f
C1310 OUT.n332 VSS 0.11683f
C1311 OUT.t934 VSS 0.01455f
C1312 OUT.n333 VSS 0.03355f
C1313 OUT.t908 VSS 0.01455f
C1314 OUT.n334 VSS 0.0318f
C1315 OUT.n335 VSS 0.11411f
C1316 OUT.n336 VSS 0.11411f
C1317 OUT.t95 VSS 0.01455f
C1318 OUT.n337 VSS 0.03282f
C1319 OUT.t70 VSS 0.01455f
C1320 OUT.n338 VSS 0.03335f
C1321 OUT.n339 VSS 0.11683f
C1322 OUT.n340 VSS 0.11683f
C1323 OUT.t46 VSS 0.01455f
C1324 OUT.n341 VSS 0.03408f
C1325 OUT.t784 VSS 0.01455f
C1326 OUT.n342 VSS 0.03282f
C1327 OUT.n343 VSS 0.11411f
C1328 OUT.n344 VSS 0.11411f
C1329 OUT.t658 VSS 0.01455f
C1330 OUT.n345 VSS 0.0328f
C1331 OUT.t634 VSS 0.01455f
C1332 OUT.n346 VSS 0.03282f
C1333 OUT.n347 VSS 0.11411f
C1334 OUT.n348 VSS 0.11411f
C1335 OUT.t608 VSS 0.01455f
C1336 OUT.n349 VSS 0.03285f
C1337 OUT.t583 VSS 0.01455f
C1338 OUT.n350 VSS 0.03388f
C1339 OUT.n351 VSS 0.11411f
C1340 OUT.n352 VSS 0.11411f
C1341 OUT.t653 VSS 0.01455f
C1342 OUT.n353 VSS 0.03289f
C1343 OUT.t510 VSS 0.01455f
C1344 OUT.n354 VSS 0.03495f
C1345 OUT.n355 VSS 0.11683f
C1346 OUT.n356 VSS 0.11683f
C1347 OUT.t487 VSS 0.01455f
C1348 OUT.n357 VSS 0.03282f
C1349 OUT.t465 VSS 0.01455f
C1350 OUT.n358 VSS 0.03335f
C1351 OUT.n359 VSS 0.11411f
C1352 OUT.n360 VSS 0.11411f
C1353 OUT.t440 VSS 0.01455f
C1354 OUT.n361 VSS 0.03287f
C1355 OUT.t162 VSS 0.01455f
C1356 OUT.n362 VSS 0.03442f
C1357 OUT.n363 VSS 0.11683f
C1358 OUT.n364 VSS 0.11683f
C1359 OUT.t13 VSS 0.01455f
C1360 OUT.n365 VSS 0.0328f
C1361 OUT.t1017 VSS 0.01455f
C1362 OUT.n366 VSS 0.03282f
C1363 OUT.n367 VSS 0.11411f
C1364 OUT.n368 VSS 0.11411f
C1365 OUT.t990 VSS 0.01455f
C1366 OUT.n369 VSS 0.03285f
C1367 OUT.t290 VSS 0.01455f
C1368 OUT.n370 VSS 0.03388f
C1369 OUT.n371 VSS 0.11411f
C1370 OUT.n372 VSS 0.11411f
C1371 OUT.t916 VSS 0.01455f
C1372 OUT.n373 VSS 0.03289f
C1373 OUT.t889 VSS 0.01455f
C1374 OUT.n374 VSS 0.03495f
C1375 OUT.n375 VSS 0.11683f
C1376 OUT.n376 VSS 0.11683f
C1377 OUT.t864 VSS 0.01455f
C1378 OUT.n377 VSS 0.03282f
C1379 OUT.t839 VSS 0.01455f
C1380 OUT.n378 VSS 0.03335f
C1381 OUT.n379 VSS 0.11683f
C1382 OUT.n380 VSS 0.11683f
C1383 OUT.t818 VSS 0.01455f
C1384 OUT.n381 VSS 0.03408f
C1385 OUT.t349 VSS 0.01455f
C1386 OUT.n382 VSS 0.03282f
C1387 OUT.n383 VSS 0.11411f
C1388 OUT.n384 VSS 0.11411f
C1389 OUT.t324 VSS 0.01455f
C1390 OUT.n385 VSS 0.0328f
C1391 OUT.t654 VSS 0.01455f
C1392 OUT.n386 VSS 0.03282f
C1393 OUT.n387 VSS 0.11411f
C1394 OUT.n388 VSS 0.11411f
C1395 OUT.t630 VSS 0.01455f
C1396 OUT.n389 VSS 0.03285f
C1397 OUT.t229 VSS 0.01455f
C1398 OUT.n390 VSS 0.03388f
C1399 OUT.n391 VSS 0.11683f
C1400 OUT.n392 VSS 0.11683f
C1401 OUT.t263 VSS 0.01455f
C1402 OUT.n393 VSS 0.03355f
C1403 OUT.t282 VSS 0.01455f
C1404 OUT.n394 VSS 0.0318f
C1405 OUT.n395 VSS 0.12616f
C1406 OUT.n396 VSS 0.19328f
C1407 OUT.n397 VSS 0.09129f
C1408 OUT.n398 VSS 0.03912f
C1409 OUT.n399 VSS 0.1804f
C1410 OUT.t170 VSS 0.01473f
C1411 OUT.t725 VSS 0.01481f
C1412 OUT.n400 VSS 0.33145f
C1413 OUT.t455 VSS 0.01455f
C1414 OUT.n401 VSS 0.03189f
C1415 OUT.t436 VSS 0.01455f
C1416 OUT.n402 VSS 0.03242f
C1417 OUT.n403 VSS 0.11411f
C1418 OUT.n404 VSS 0.11411f
C1419 OUT.t410 VSS 0.01455f
C1420 OUT.n405 VSS 0.03264f
C1421 OUT.t269 VSS 0.01455f
C1422 OUT.n406 VSS 0.0321f
C1423 OUT.n407 VSS 0.11683f
C1424 OUT.n408 VSS 0.11683f
C1425 OUT.t249 VSS 0.01455f
C1426 OUT.n409 VSS 0.03157f
C1427 OUT.t981 VSS 0.01455f
C1428 OUT.n410 VSS 0.03264f
C1429 OUT.n411 VSS 0.11411f
C1430 OUT.n412 VSS 0.11411f
C1431 OUT.t959 VSS 0.01455f
C1432 OUT.n413 VSS 0.03264f
C1433 OUT.t261 VSS 0.01455f
C1434 OUT.n414 VSS 0.03264f
C1435 OUT.n415 VSS 0.11683f
C1436 OUT.n416 VSS 0.11683f
C1437 OUT.t120 VSS 0.01455f
C1438 OUT.n417 VSS 0.03104f
C1439 OUT.t97 VSS 0.01455f
C1440 OUT.n418 VSS 0.03264f
C1441 OUT.n419 VSS 0.11411f
C1442 OUT.n420 VSS 0.11411f
C1443 OUT.t836 VSS 0.01455f
C1444 OUT.n421 VSS 0.0321f
C1445 OUT.t810 VSS 0.01455f
C1446 OUT.n422 VSS 0.03264f
C1447 OUT.n423 VSS 0.11411f
C1448 OUT.n424 VSS 0.11411f
C1449 OUT.t789 VSS 0.01455f
C1450 OUT.n425 VSS 0.03242f
C1451 OUT.t850 VSS 0.01455f
C1452 OUT.n426 VSS 0.03189f
C1453 OUT.n427 VSS 0.11683f
C1454 OUT.n428 VSS 0.11683f
C1455 OUT.t823 VSS 0.01455f
C1456 OUT.n429 VSS 0.03136f
C1457 OUT.t893 VSS 0.01455f
C1458 OUT.n430 VSS 0.03242f
C1459 OUT.n431 VSS 0.11411f
C1460 OUT.n432 VSS 0.11411f
C1461 OUT.t868 VSS 0.01455f
C1462 OUT.n433 VSS 0.03242f
C1463 OUT.t723 VSS 0.01455f
C1464 OUT.n434 VSS 0.03242f
C1465 OUT.n435 VSS 0.11683f
C1466 OUT.n436 VSS 0.11683f
C1467 OUT.t704 VSS 0.01455f
C1468 OUT.n437 VSS 0.03082f
C1469 OUT.t684 VSS 0.01455f
C1470 OUT.n438 VSS 0.03242f
C1471 OUT.n439 VSS 0.11411f
C1472 OUT.n440 VSS 0.11411f
C1473 OUT.t405 VSS 0.01455f
C1474 OUT.n441 VSS 0.03189f
C1475 OUT.t383 VSS 0.01455f
C1476 OUT.n442 VSS 0.03242f
C1477 OUT.n443 VSS 0.11411f
C1478 OUT.n444 VSS 0.11411f
C1479 OUT.t246 VSS 0.01455f
C1480 OUT.n445 VSS 0.03242f
C1481 OUT.t224 VSS 0.01455f
C1482 OUT.n446 VSS 0.03189f
C1483 OUT.n447 VSS 0.11683f
C1484 OUT.n448 VSS 0.11683f
C1485 OUT.t545 VSS 0.01455f
C1486 OUT.n449 VSS 0.03136f
C1487 OUT.t262 VSS 0.01455f
C1488 OUT.n450 VSS 0.03242f
C1489 OUT.n451 VSS 0.11411f
C1490 OUT.n452 VSS 0.11411f
C1491 OUT.t241 VSS 0.01455f
C1492 OUT.n453 VSS 0.03242f
C1493 OUT.t98 VSS 0.01455f
C1494 OUT.n454 VSS 0.03242f
C1495 OUT.n455 VSS 0.11411f
C1496 OUT.n456 VSS 0.11411f
C1497 OUT.t72 VSS 0.01455f
C1498 OUT.n457 VSS 0.03242f
C1499 OUT.t50 VSS 0.01455f
C1500 OUT.n458 VSS 0.03136f
C1501 OUT.n459 VSS 0.11683f
C1502 OUT.n460 VSS 0.11683f
C1503 OUT.t790 VSS 0.01455f
C1504 OUT.n461 VSS 0.03189f
C1505 OUT.t760 VSS 0.01455f
C1506 OUT.n462 VSS 0.03242f
C1507 OUT.n463 VSS 0.11411f
C1508 OUT.n464 VSS 0.11411f
C1509 OUT.t970 VSS 0.01455f
C1510 OUT.n465 VSS 0.03242f
C1511 OUT.t947 VSS 0.01455f
C1512 OUT.n466 VSS 0.03189f
C1513 OUT.n467 VSS 0.11683f
C1514 OUT.n468 VSS 0.11683f
C1515 OUT.t927 VSS 0.01455f
C1516 OUT.n469 VSS 0.03136f
C1517 OUT.t652 VSS 0.01455f
C1518 OUT.n470 VSS 0.03242f
C1519 OUT.n471 VSS 0.11411f
C1520 OUT.n472 VSS 0.11411f
C1521 OUT.t512 VSS 0.01455f
C1522 OUT.n473 VSS 0.03242f
C1523 OUT.t489 VSS 0.01455f
C1524 OUT.n474 VSS 0.03242f
C1525 OUT.n475 VSS 0.11411f
C1526 OUT.n476 VSS 0.11411f
C1527 OUT.t466 VSS 0.01455f
C1528 OUT.n477 VSS 0.03242f
C1529 OUT.t442 VSS 0.01455f
C1530 OUT.n478 VSS 0.03136f
C1531 OUT.n479 VSS 0.11411f
C1532 OUT.n480 VSS 0.11411f
C1533 OUT.t505 VSS 0.01455f
C1534 OUT.n481 VSS 0.03242f
C1535 OUT.t362 VSS 0.01455f
C1536 OUT.n482 VSS 0.03029f
C1537 OUT.n483 VSS 0.11683f
C1538 OUT.n484 VSS 0.11683f
C1539 OUT.t337 VSS 0.01455f
C1540 OUT.n485 VSS 0.03242f
C1541 OUT.t313 VSS 0.01455f
C1542 OUT.n486 VSS 0.03189f
C1543 OUT.n487 VSS 0.11411f
C1544 OUT.n488 VSS 0.11411f
C1545 OUT.t289 VSS 0.01455f
C1546 OUT.n489 VSS 0.03242f
C1547 OUT.t8 VSS 0.01455f
C1548 OUT.n490 VSS 0.03082f
C1549 OUT.n491 VSS 0.11683f
C1550 OUT.n492 VSS 0.11683f
C1551 OUT.t888 VSS 0.01455f
C1552 OUT.n493 VSS 0.03242f
C1553 OUT.t863 VSS 0.01455f
C1554 OUT.n494 VSS 0.03242f
C1555 OUT.n495 VSS 0.11411f
C1556 OUT.n496 VSS 0.11411f
C1557 OUT.t838 VSS 0.01455f
C1558 OUT.n497 VSS 0.03242f
C1559 OUT.t148 VSS 0.01455f
C1560 OUT.n498 VSS 0.03136f
C1561 OUT.n499 VSS 0.11411f
C1562 OUT.n500 VSS 0.11411f
C1563 OUT.t768 VSS 0.01455f
C1564 OUT.n501 VSS 0.03242f
C1565 OUT.t740 VSS 0.01455f
C1566 OUT.n502 VSS 0.03029f
C1567 OUT.n503 VSS 0.11683f
C1568 OUT.n504 VSS 0.11683f
C1569 OUT.t715 VSS 0.01455f
C1570 OUT.n505 VSS 0.03242f
C1571 OUT.t695 VSS 0.01455f
C1572 OUT.n506 VSS 0.03189f
C1573 OUT.n507 VSS 0.11683f
C1574 OUT.n508 VSS 0.11683f
C1575 OUT.t676 VSS 0.01455f
C1576 OUT.n509 VSS 0.03136f
C1577 OUT.t211 VSS 0.01455f
C1578 OUT.n510 VSS 0.03242f
C1579 OUT.n511 VSS 0.11411f
C1580 OUT.n512 VSS 0.11411f
C1581 OUT.t192 VSS 0.01455f
C1582 OUT.n513 VSS 0.03242f
C1583 OUT.t506 VSS 0.01455f
C1584 OUT.n514 VSS 0.03242f
C1585 OUT.n515 VSS 0.11411f
C1586 OUT.n516 VSS 0.11411f
C1587 OUT.t483 VSS 0.01455f
C1588 OUT.n517 VSS 0.03242f
C1589 OUT.t79 VSS 0.01455f
C1590 OUT.n518 VSS 0.03136f
C1591 OUT.n519 VSS 0.11683f
C1592 OUT.n520 VSS 0.11683f
C1593 OUT.t119 VSS 0.01455f
C1594 OUT.n521 VSS 0.03189f
C1595 OUT.t145 VSS 0.01455f
C1596 OUT.n522 VSS 0.03242f
C1597 OUT.n523 VSS 0.12616f
C1598 OUT.n524 VSS 0.1935f
C1599 OUT.n525 VSS 0.08751f
C1600 OUT.n526 VSS 0.55099f
C1601 OUT.n527 VSS 0.55099f
C1602 OUT.n528 VSS 0.20214f
C1603 OUT.n529 VSS 0.55099f
C1604 OUT.n530 VSS 0.57218f
C1605 OUT.n531 VSS 1.09812f
C1606 OUT.n532 VSS 0.1435f
C1607 OUT.n533 VSS 0.09129f
C1608 OUT.n534 VSS 0.55099f
C1609 OUT.n535 VSS 0.13041f
C1610 OUT.t446 VSS 0.01473f
C1611 OUT.t1013 VSS 0.01481f
C1612 OUT.n536 VSS 0.33124f
C1613 OUT.t722 VSS 0.01455f
C1614 OUT.n537 VSS 0.03331f
C1615 OUT.t703 VSS 0.01455f
C1616 OUT.n538 VSS 0.03205f
C1617 OUT.n539 VSS 0.11411f
C1618 OUT.n540 VSS 0.11411f
C1619 OUT.t683 VSS 0.01455f
C1620 OUT.n541 VSS 0.03277f
C1621 OUT.t550 VSS 0.01455f
C1622 OUT.n542 VSS 0.0333f
C1623 OUT.n543 VSS 0.11683f
C1624 OUT.n544 VSS 0.11683f
C1625 OUT.t528 VSS 0.01455f
C1626 OUT.n545 VSS 0.03406f
C1627 OUT.t245 VSS 0.01455f
C1628 OUT.n546 VSS 0.03277f
C1629 OUT.n547 VSS 0.11411f
C1630 OUT.n548 VSS 0.11411f
C1631 OUT.t223 VSS 0.01455f
C1632 OUT.n549 VSS 0.03277f
C1633 OUT.t542 VSS 0.01455f
C1634 OUT.n550 VSS 0.03277f
C1635 OUT.n551 VSS 0.11683f
C1636 OUT.n552 VSS 0.11683f
C1637 OUT.t401 VSS 0.01455f
C1638 OUT.n553 VSS 0.03459f
C1639 OUT.t380 VSS 0.01455f
C1640 OUT.n554 VSS 0.03278f
C1641 OUT.n555 VSS 0.11411f
C1642 OUT.n556 VSS 0.11411f
C1643 OUT.t94 VSS 0.01455f
C1644 OUT.n557 VSS 0.03352f
C1645 OUT.t69 VSS 0.01455f
C1646 OUT.n558 VSS 0.03226f
C1647 OUT.n559 VSS 0.11411f
C1648 OUT.n560 VSS 0.11411f
C1649 OUT.t44 VSS 0.01455f
C1650 OUT.n561 VSS 0.03256f
C1651 OUT.t108 VSS 0.01455f
C1652 OUT.n562 VSS 0.03309f
C1653 OUT.n563 VSS 0.11683f
C1654 OUT.n564 VSS 0.11683f
C1655 OUT.t81 VSS 0.01455f
C1656 OUT.n565 VSS 0.03384f
C1657 OUT.t154 VSS 0.01455f
C1658 OUT.n566 VSS 0.03256f
C1659 OUT.n567 VSS 0.11411f
C1660 OUT.n568 VSS 0.11411f
C1661 OUT.t127 VSS 0.01455f
C1662 OUT.n569 VSS 0.03255f
C1663 OUT.t1010 VSS 0.01455f
C1664 OUT.n570 VSS 0.03256f
C1665 OUT.n571 VSS 0.11683f
C1666 OUT.n572 VSS 0.11683f
C1667 OUT.t988 VSS 0.01455f
C1668 OUT.n573 VSS 0.03438f
C1669 OUT.t961 VSS 0.01455f
C1670 OUT.n574 VSS 0.03257f
C1671 OUT.n575 VSS 0.11411f
C1672 OUT.n576 VSS 0.11411f
C1673 OUT.t681 VSS 0.01455f
C1674 OUT.n577 VSS 0.03331f
C1675 OUT.t664 VSS 0.01455f
C1676 OUT.n578 VSS 0.03205f
C1677 OUT.n579 VSS 0.11411f
C1678 OUT.n580 VSS 0.11411f
C1679 OUT.t527 VSS 0.01455f
C1680 OUT.n581 VSS 0.03256f
C1681 OUT.t504 VSS 0.01455f
C1682 OUT.n582 VSS 0.03309f
C1683 OUT.n583 VSS 0.11683f
C1684 OUT.n584 VSS 0.11683f
C1685 OUT.t814 VSS 0.01455f
C1686 OUT.n585 VSS 0.03384f
C1687 OUT.t543 VSS 0.01455f
C1688 OUT.n586 VSS 0.03256f
C1689 OUT.n587 VSS 0.11411f
C1690 OUT.n588 VSS 0.11411f
C1691 OUT.t522 VSS 0.01455f
C1692 OUT.n589 VSS 0.03255f
C1693 OUT.t377 VSS 0.01455f
C1694 OUT.n590 VSS 0.03256f
C1695 OUT.n591 VSS 0.11411f
C1696 OUT.n592 VSS 0.11411f
C1697 OUT.t352 VSS 0.01455f
C1698 OUT.n593 VSS 0.03257f
C1699 OUT.t327 VSS 0.01455f
C1700 OUT.n594 VSS 0.03362f
C1701 OUT.n595 VSS 0.11683f
C1702 OUT.n596 VSS 0.11683f
C1703 OUT.t45 VSS 0.01455f
C1704 OUT.n597 VSS 0.03331f
C1705 OUT.t20 VSS 0.01455f
C1706 OUT.n598 VSS 0.03205f
C1707 OUT.n599 VSS 0.11411f
C1708 OUT.n600 VSS 0.11411f
C1709 OUT.t237 VSS 0.01455f
C1710 OUT.n601 VSS 0.03256f
C1711 OUT.t215 VSS 0.01455f
C1712 OUT.n602 VSS 0.03309f
C1713 OUT.n603 VSS 0.11683f
C1714 OUT.n604 VSS 0.11683f
C1715 OUT.t194 VSS 0.01455f
C1716 OUT.n605 VSS 0.03384f
C1717 OUT.t923 VSS 0.01455f
C1718 OUT.n606 VSS 0.03256f
C1719 OUT.n607 VSS 0.11411f
C1720 OUT.n608 VSS 0.11411f
C1721 OUT.t781 VSS 0.01455f
C1722 OUT.n609 VSS 0.03255f
C1723 OUT.t756 VSS 0.01455f
C1724 OUT.n610 VSS 0.03256f
C1725 OUT.n611 VSS 0.11411f
C1726 OUT.n612 VSS 0.11411f
C1727 OUT.t730 VSS 0.01455f
C1728 OUT.n613 VSS 0.03257f
C1729 OUT.t708 VSS 0.01455f
C1730 OUT.n614 VSS 0.03362f
C1731 OUT.n615 VSS 0.11411f
C1732 OUT.n616 VSS 0.11411f
C1733 OUT.t773 VSS 0.01455f
C1734 OUT.n617 VSS 0.0326f
C1735 OUT.t646 VSS 0.01455f
C1736 OUT.n618 VSS 0.03469f
C1737 OUT.n619 VSS 0.11683f
C1738 OUT.n620 VSS 0.11683f
C1739 OUT.t624 VSS 0.01455f
C1740 OUT.n621 VSS 0.03256f
C1741 OUT.t597 VSS 0.01455f
C1742 OUT.n622 VSS 0.03309f
C1743 OUT.n623 VSS 0.11411f
C1744 OUT.n624 VSS 0.11411f
C1745 OUT.t573 VSS 0.01455f
C1746 OUT.n625 VSS 0.03258f
C1747 OUT.t285 VSS 0.01455f
C1748 OUT.n626 VSS 0.03415f
C1749 OUT.n627 VSS 0.11683f
C1750 OUT.n628 VSS 0.11683f
C1751 OUT.t151 VSS 0.01455f
C1752 OUT.n629 VSS 0.03255f
C1753 OUT.t125 VSS 0.01455f
C1754 OUT.n630 VSS 0.03256f
C1755 OUT.n631 VSS 0.11411f
C1756 OUT.n632 VSS 0.11411f
C1757 OUT.t101 VSS 0.01455f
C1758 OUT.n633 VSS 0.03257f
C1759 OUT.t429 VSS 0.01455f
C1760 OUT.n634 VSS 0.03362f
C1761 OUT.n635 VSS 0.11411f
C1762 OUT.n636 VSS 0.11411f
C1763 OUT.t26 VSS 0.01455f
C1764 OUT.n637 VSS 0.0326f
C1765 OUT.t1024 VSS 0.01455f
C1766 OUT.n638 VSS 0.03469f
C1767 OUT.n639 VSS 0.11683f
C1768 OUT.n640 VSS 0.11683f
C1769 OUT.t1001 VSS 0.01455f
C1770 OUT.n641 VSS 0.03256f
C1771 OUT.t976 VSS 0.01455f
C1772 OUT.n642 VSS 0.03309f
C1773 OUT.n643 VSS 0.11683f
C1774 OUT.n644 VSS 0.11683f
C1775 OUT.t954 VSS 0.01455f
C1776 OUT.n645 VSS 0.03384f
C1777 OUT.t486 VSS 0.01455f
C1778 OUT.n646 VSS 0.03256f
C1779 OUT.n647 VSS 0.11411f
C1780 OUT.n648 VSS 0.11411f
C1781 OUT.t464 VSS 0.01455f
C1782 OUT.n649 VSS 0.03255f
C1783 OUT.t774 VSS 0.01455f
C1784 OUT.n650 VSS 0.03256f
C1785 OUT.n651 VSS 0.11411f
C1786 OUT.n652 VSS 0.11411f
C1787 OUT.t749 VSS 0.01455f
C1788 OUT.n653 VSS 0.03257f
C1789 OUT.t359 VSS 0.01455f
C1790 OUT.n654 VSS 0.03362f
C1791 OUT.n655 VSS 0.11683f
C1792 OUT.n656 VSS 0.11683f
C1793 OUT.t398 VSS 0.01455f
C1794 OUT.n657 VSS 0.03331f
C1795 OUT.t425 VSS 0.01455f
C1796 OUT.n658 VSS 0.03205f
C1797 OUT.n659 VSS 0.12616f
C1798 OUT.n660 VSS 0.19327f
C1799 OUT.n661 VSS 0.17444f
C1800 OUT.t251 VSS 0.01473f
C1801 OUT.t813 VSS 0.01481f
C1802 OUT.n662 VSS 0.33133f
C1803 OUT.t540 VSS 0.01455f
C1804 OUT.n663 VSS 0.03307f
C1805 OUT.t519 VSS 0.01455f
C1806 OUT.n664 VSS 0.0323f
C1807 OUT.n665 VSS 0.11411f
C1808 OUT.n666 VSS 0.11411f
C1809 OUT.t494 VSS 0.01455f
C1810 OUT.n667 VSS 0.03251f
C1811 OUT.t351 VSS 0.01455f
C1812 OUT.n668 VSS 0.03329f
C1813 OUT.n669 VSS 0.11683f
C1814 OUT.n670 VSS 0.11683f
C1815 OUT.t326 VSS 0.01455f
C1816 OUT.n671 VSS 0.03381f
C1817 OUT.t43 VSS 0.01455f
C1818 OUT.n672 VSS 0.03251f
C1819 OUT.n673 VSS 0.11411f
C1820 OUT.n674 VSS 0.11411f
C1821 OUT.t19 VSS 0.01455f
C1822 OUT.n675 VSS 0.03251f
C1823 OUT.t343 VSS 0.01455f
C1824 OUT.n676 VSS 0.03251f
C1825 OUT.n677 VSS 0.11683f
C1826 OUT.n678 VSS 0.11683f
C1827 OUT.t210 VSS 0.01455f
C1828 OUT.n679 VSS 0.03434f
C1829 OUT.t190 VSS 0.01455f
C1830 OUT.n680 VSS 0.03251f
C1831 OUT.n681 VSS 0.11411f
C1832 OUT.n682 VSS 0.11411f
C1833 OUT.t922 VSS 0.01455f
C1834 OUT.n683 VSS 0.03329f
C1835 OUT.t898 VSS 0.01455f
C1836 OUT.n684 VSS 0.03251f
C1837 OUT.n685 VSS 0.11411f
C1838 OUT.n686 VSS 0.11411f
C1839 OUT.t874 VSS 0.01455f
C1840 OUT.n687 VSS 0.03242f
C1841 OUT.t937 VSS 0.01455f
C1842 OUT.n688 VSS 0.0332f
C1843 OUT.n689 VSS 0.11683f
C1844 OUT.n690 VSS 0.11683f
C1845 OUT.t910 VSS 0.01455f
C1846 OUT.n691 VSS 0.03371f
C1847 OUT.t975 VSS 0.01455f
C1848 OUT.n692 VSS 0.03242f
C1849 OUT.n693 VSS 0.11411f
C1850 OUT.n694 VSS 0.11411f
C1851 OUT.t953 VSS 0.01455f
C1852 OUT.n695 VSS 0.03217f
C1853 OUT.t809 VSS 0.01455f
C1854 OUT.n696 VSS 0.03242f
C1855 OUT.n697 VSS 0.11683f
C1856 OUT.n698 VSS 0.11683f
C1857 OUT.t788 VSS 0.01455f
C1858 OUT.n699 VSS 0.03425f
C1859 OUT.t759 VSS 0.01455f
C1860 OUT.n700 VSS 0.03243f
C1861 OUT.n701 VSS 0.11411f
C1862 OUT.n702 VSS 0.11411f
C1863 OUT.t495 VSS 0.01455f
C1864 OUT.n703 VSS 0.03319f
C1865 OUT.t471 VSS 0.01455f
C1866 OUT.n704 VSS 0.03217f
C1867 OUT.n705 VSS 0.11411f
C1868 OUT.n706 VSS 0.11411f
C1869 OUT.t323 VSS 0.01455f
C1870 OUT.n707 VSS 0.03242f
C1871 OUT.t301 VSS 0.01455f
C1872 OUT.n708 VSS 0.0332f
C1873 OUT.n709 VSS 0.11683f
C1874 OUT.n710 VSS 0.11683f
C1875 OUT.t631 VSS 0.01455f
C1876 OUT.n711 VSS 0.03371f
C1877 OUT.t341 VSS 0.01455f
C1878 OUT.n712 VSS 0.03242f
C1879 OUT.n713 VSS 0.11411f
C1880 OUT.n714 VSS 0.11411f
C1881 OUT.t319 VSS 0.01455f
C1882 OUT.n715 VSS 0.03217f
C1883 OUT.t191 VSS 0.01455f
C1884 OUT.n716 VSS 0.03242f
C1885 OUT.n717 VSS 0.11411f
C1886 OUT.n718 VSS 0.11411f
C1887 OUT.t164 VSS 0.01455f
C1888 OUT.n719 VSS 0.03243f
C1889 OUT.t136 VSS 0.01455f
C1890 OUT.n720 VSS 0.03372f
C1891 OUT.n721 VSS 0.11683f
C1892 OUT.n722 VSS 0.11683f
C1893 OUT.t872 VSS 0.01455f
C1894 OUT.n723 VSS 0.03319f
C1895 OUT.t844 VSS 0.01455f
C1896 OUT.n724 VSS 0.03217f
C1897 OUT.n725 VSS 0.11411f
C1898 OUT.n726 VSS 0.11411f
C1899 OUT.t34 VSS 0.01455f
C1900 OUT.n727 VSS 0.03242f
C1901 OUT.t7 VSS 0.01455f
C1902 OUT.n728 VSS 0.0332f
C1903 OUT.n729 VSS 0.11683f
C1904 OUT.n730 VSS 0.11683f
C1905 OUT.t1009 VSS 0.01455f
C1906 OUT.n731 VSS 0.03371f
C1907 OUT.t720 VSS 0.01455f
C1908 OUT.n732 VSS 0.03242f
C1909 OUT.n733 VSS 0.11411f
C1910 OUT.n734 VSS 0.11411f
C1911 OUT.t594 VSS 0.01455f
C1912 OUT.n735 VSS 0.03217f
C1913 OUT.t570 VSS 0.01455f
C1914 OUT.n736 VSS 0.03242f
C1915 OUT.n737 VSS 0.11411f
C1916 OUT.n738 VSS 0.11411f
C1917 OUT.t547 VSS 0.01455f
C1918 OUT.n739 VSS 0.03243f
C1919 OUT.t526 VSS 0.01455f
C1920 OUT.n740 VSS 0.03372f
C1921 OUT.n741 VSS 0.11411f
C1922 OUT.n742 VSS 0.11411f
C1923 OUT.t588 VSS 0.01455f
C1924 OUT.n743 VSS 0.03244f
C1925 OUT.t448 VSS 0.01455f
C1926 OUT.n744 VSS 0.03478f
C1927 OUT.n745 VSS 0.11683f
C1928 OUT.n746 VSS 0.11683f
C1929 OUT.t428 VSS 0.01455f
C1930 OUT.n747 VSS 0.03242f
C1931 OUT.t399 VSS 0.01455f
C1932 OUT.n748 VSS 0.0332f
C1933 OUT.n749 VSS 0.11411f
C1934 OUT.n750 VSS 0.11411f
C1935 OUT.t376 VSS 0.01455f
C1936 OUT.n751 VSS 0.03244f
C1937 OUT.t93 VSS 0.01455f
C1938 OUT.n752 VSS 0.03426f
C1939 OUT.n753 VSS 0.11683f
C1940 OUT.n754 VSS 0.11683f
C1941 OUT.t973 VSS 0.01455f
C1942 OUT.n755 VSS 0.03217f
C1943 OUT.t950 VSS 0.01455f
C1944 OUT.n756 VSS 0.03242f
C1945 OUT.n757 VSS 0.11411f
C1946 OUT.n758 VSS 0.11411f
C1947 OUT.t930 VSS 0.01455f
C1948 OUT.n759 VSS 0.03243f
C1949 OUT.t236 VSS 0.01455f
C1950 OUT.n760 VSS 0.03372f
C1951 OUT.n761 VSS 0.11411f
C1952 OUT.n762 VSS 0.11411f
C1953 OUT.t852 VSS 0.01455f
C1954 OUT.n763 VSS 0.03244f
C1955 OUT.t826 VSS 0.01455f
C1956 OUT.n764 VSS 0.03478f
C1957 OUT.n765 VSS 0.11683f
C1958 OUT.n766 VSS 0.11683f
C1959 OUT.t805 VSS 0.01455f
C1960 OUT.n767 VSS 0.03242f
C1961 OUT.t780 VSS 0.01455f
C1962 OUT.n768 VSS 0.0332f
C1963 OUT.n769 VSS 0.11683f
C1964 OUT.n770 VSS 0.11683f
C1965 OUT.t755 VSS 0.01455f
C1966 OUT.n771 VSS 0.03371f
C1967 OUT.t284 VSS 0.01455f
C1968 OUT.n772 VSS 0.03242f
C1969 OUT.n773 VSS 0.11411f
C1970 OUT.n774 VSS 0.11411f
C1971 OUT.t265 VSS 0.01455f
C1972 OUT.n775 VSS 0.03217f
C1973 OUT.t589 VSS 0.01455f
C1974 OUT.n776 VSS 0.03242f
C1975 OUT.n777 VSS 0.11411f
C1976 OUT.n778 VSS 0.11411f
C1977 OUT.t567 VSS 0.01455f
C1978 OUT.n779 VSS 0.03243f
C1979 OUT.t169 VSS 0.01455f
C1980 OUT.n780 VSS 0.03372f
C1981 OUT.n781 VSS 0.11683f
C1982 OUT.n782 VSS 0.11683f
C1983 OUT.t206 VSS 0.01455f
C1984 OUT.n783 VSS 0.03319f
C1985 OUT.t228 VSS 0.01455f
C1986 OUT.n784 VSS 0.03217f
C1987 OUT.n785 VSS 0.12616f
C1988 OUT.n786 VSS 0.19338f
C1989 OUT.n787 VSS 0.17445f
C1990 OUT.n788 VSS 0.13041f
C1991 OUT.n789 VSS 0.20648f
C1992 OUT.n790 VSS 0.55099f
C1993 OUT.n791 VSS 0.55099f
C1994 OUT.n792 VSS 0.55099f
C1995 OUT.n793 VSS 0.16736f
C1996 OUT.t820 VSS 0.01473f
C1997 OUT.t366 VSS 0.01481f
C1998 OUT.n794 VSS 0.33121f
C1999 OUT.t83 VSS 0.01455f
C2000 OUT.n795 VSS 0.03307f
C2001 OUT.t63 VSS 0.01455f
C2002 OUT.n796 VSS 0.0323f
C2003 OUT.n797 VSS 0.11411f
C2004 OUT.n798 VSS 0.11411f
C2005 OUT.t38 VSS 0.01455f
C2006 OUT.n799 VSS 0.03251f
C2007 OUT.t921 VSS 0.01455f
C2008 OUT.n800 VSS 0.03198f
C2009 OUT.n801 VSS 0.11683f
C2010 OUT.n802 VSS 0.11683f
C2011 OUT.t896 VSS 0.01455f
C2012 OUT.n803 VSS 0.03145f
C2013 OUT.t627 VSS 0.01455f
C2014 OUT.n804 VSS 0.03251f
C2015 OUT.n805 VSS 0.11411f
C2016 OUT.n806 VSS 0.11411f
C2017 OUT.t602 VSS 0.01455f
C2018 OUT.n807 VSS 0.03251f
C2019 OUT.t917 VSS 0.01455f
C2020 OUT.n808 VSS 0.03251f
C2021 OUT.n809 VSS 0.11683f
C2022 OUT.n810 VSS 0.11683f
C2023 OUT.t772 VSS 0.01455f
C2024 OUT.n811 VSS 0.03092f
C2025 OUT.t747 VSS 0.01455f
C2026 OUT.n812 VSS 0.03251f
C2027 OUT.n813 VSS 0.11411f
C2028 OUT.n814 VSS 0.11411f
C2029 OUT.t480 VSS 0.01455f
C2030 OUT.n815 VSS 0.03198f
C2031 OUT.t454 VSS 0.01455f
C2032 OUT.n816 VSS 0.03251f
C2033 OUT.n817 VSS 0.11411f
C2034 OUT.n818 VSS 0.11411f
C2035 OUT.t435 VSS 0.01455f
C2036 OUT.n819 VSS 0.0323f
C2037 OUT.t493 VSS 0.01455f
C2038 OUT.n820 VSS 0.03176f
C2039 OUT.n821 VSS 0.11683f
C2040 OUT.n822 VSS 0.11683f
C2041 OUT.t470 VSS 0.01455f
C2042 OUT.n823 VSS 0.03124f
C2043 OUT.t533 VSS 0.01455f
C2044 OUT.n824 VSS 0.0323f
C2045 OUT.n825 VSS 0.11411f
C2046 OUT.n826 VSS 0.11411f
C2047 OUT.t508 VSS 0.01455f
C2048 OUT.n827 VSS 0.0323f
C2049 OUT.t367 VSS 0.01455f
C2050 OUT.n828 VSS 0.0323f
C2051 OUT.n829 VSS 0.11683f
C2052 OUT.n830 VSS 0.11683f
C2053 OUT.t342 VSS 0.01455f
C2054 OUT.n831 VSS 0.0307f
C2055 OUT.t320 VSS 0.01455f
C2056 OUT.n832 VSS 0.0323f
C2057 OUT.n833 VSS 0.11411f
C2058 OUT.n834 VSS 0.11411f
C2059 OUT.t37 VSS 0.01455f
C2060 OUT.n835 VSS 0.03177f
C2061 OUT.t12 VSS 0.01455f
C2062 OUT.n836 VSS 0.0323f
C2063 OUT.n837 VSS 0.11411f
C2064 OUT.n838 VSS 0.11411f
C2065 OUT.t897 VSS 0.01455f
C2066 OUT.n839 VSS 0.0323f
C2067 OUT.t873 VSS 0.01455f
C2068 OUT.n840 VSS 0.03176f
C2069 OUT.n841 VSS 0.11683f
C2070 OUT.n842 VSS 0.11683f
C2071 OUT.t183 VSS 0.01455f
C2072 OUT.n843 VSS 0.03124f
C2073 OUT.t915 VSS 0.01455f
C2074 OUT.n844 VSS 0.0323f
C2075 OUT.n845 VSS 0.11411f
C2076 OUT.n846 VSS 0.11411f
C2077 OUT.t887 VSS 0.01455f
C2078 OUT.n847 VSS 0.0323f
C2079 OUT.t744 VSS 0.01455f
C2080 OUT.n848 VSS 0.0323f
C2081 OUT.n849 VSS 0.11411f
C2082 OUT.n850 VSS 0.11411f
C2083 OUT.t719 VSS 0.01455f
C2084 OUT.n851 VSS 0.0323f
C2085 OUT.t702 VSS 0.01455f
C2086 OUT.n852 VSS 0.03123f
C2087 OUT.n853 VSS 0.11683f
C2088 OUT.n854 VSS 0.11683f
C2089 OUT.t432 VSS 0.01455f
C2090 OUT.n855 VSS 0.03177f
C2091 OUT.t402 VSS 0.01455f
C2092 OUT.n856 VSS 0.0323f
C2093 OUT.n857 VSS 0.11411f
C2094 OUT.n858 VSS 0.11411f
C2095 OUT.t615 VSS 0.01455f
C2096 OUT.n859 VSS 0.0323f
C2097 OUT.t587 VSS 0.01455f
C2098 OUT.n860 VSS 0.03176f
C2099 OUT.n861 VSS 0.11683f
C2100 OUT.n862 VSS 0.11683f
C2101 OUT.t566 VSS 0.01455f
C2102 OUT.n863 VSS 0.03124f
C2103 OUT.t281 VSS 0.01455f
C2104 OUT.n864 VSS 0.0323f
C2105 OUT.n865 VSS 0.11411f
C2106 OUT.n866 VSS 0.11411f
C2107 OUT.t144 VSS 0.01455f
C2108 OUT.n867 VSS 0.0323f
C2109 OUT.t118 VSS 0.01455f
C2110 OUT.n868 VSS 0.0323f
C2111 OUT.n869 VSS 0.11411f
C2112 OUT.n870 VSS 0.11411f
C2113 OUT.t92 VSS 0.01455f
C2114 OUT.n871 VSS 0.0323f
C2115 OUT.t68 VSS 0.01455f
C2116 OUT.n872 VSS 0.03123f
C2117 OUT.n873 VSS 0.11411f
C2118 OUT.n874 VSS 0.11411f
C2119 OUT.t141 VSS 0.01455f
C2120 OUT.n875 VSS 0.0323f
C2121 OUT.t1021 VSS 0.01455f
C2122 OUT.n876 VSS 0.03017f
C2123 OUT.n877 VSS 0.11683f
C2124 OUT.n878 VSS 0.11683f
C2125 OUT.t997 VSS 0.01455f
C2126 OUT.n879 VSS 0.0323f
C2127 OUT.t967 VSS 0.01455f
C2128 OUT.n880 VSS 0.03176f
C2129 OUT.n881 VSS 0.11411f
C2130 OUT.n882 VSS 0.11411f
C2131 OUT.t945 VSS 0.01455f
C2132 OUT.n883 VSS 0.0323f
C2133 OUT.t667 VSS 0.01455f
C2134 OUT.n884 VSS 0.0307f
C2135 OUT.n885 VSS 0.11683f
C2136 OUT.n886 VSS 0.11683f
C2137 OUT.t534 VSS 0.01455f
C2138 OUT.n887 VSS 0.0323f
C2139 OUT.t509 VSS 0.01455f
C2140 OUT.n888 VSS 0.0323f
C2141 OUT.n889 VSS 0.11411f
C2142 OUT.n890 VSS 0.11411f
C2143 OUT.t485 VSS 0.01455f
C2144 OUT.n891 VSS 0.0323f
C2145 OUT.t797 VSS 0.01455f
C2146 OUT.n892 VSS 0.03123f
C2147 OUT.n893 VSS 0.11411f
C2148 OUT.n894 VSS 0.11411f
C2149 OUT.t411 VSS 0.01455f
C2150 OUT.n895 VSS 0.0323f
C2151 OUT.t384 VSS 0.01455f
C2152 OUT.n896 VSS 0.03017f
C2153 OUT.n897 VSS 0.11683f
C2154 OUT.n898 VSS 0.11683f
C2155 OUT.t360 VSS 0.01455f
C2156 OUT.n899 VSS 0.0323f
C2157 OUT.t336 VSS 0.01455f
C2158 OUT.n900 VSS 0.03176f
C2159 OUT.n901 VSS 0.11683f
C2160 OUT.n902 VSS 0.11683f
C2161 OUT.t309 VSS 0.01455f
C2162 OUT.n903 VSS 0.03124f
C2163 OUT.t855 VSS 0.01455f
C2164 OUT.n904 VSS 0.0323f
C2165 OUT.n905 VSS 0.11411f
C2166 OUT.n906 VSS 0.11411f
C2167 OUT.t833 VSS 0.01455f
C2168 OUT.n907 VSS 0.0323f
C2169 OUT.t142 VSS 0.01455f
C2170 OUT.n908 VSS 0.0323f
C2171 OUT.n909 VSS 0.11411f
C2172 OUT.n910 VSS 0.11411f
C2173 OUT.t113 VSS 0.01455f
C2174 OUT.n911 VSS 0.0323f
C2175 OUT.t729 VSS 0.01455f
C2176 OUT.n912 VSS 0.03123f
C2177 OUT.n913 VSS 0.11683f
C2178 OUT.n914 VSS 0.11683f
C2179 OUT.t770 VSS 0.01455f
C2180 OUT.n915 VSS 0.03177f
C2181 OUT.t795 VSS 0.01455f
C2182 OUT.n916 VSS 0.0323f
C2183 OUT.n917 VSS 0.12616f
C2184 OUT.n918 VSS 0.19326f
C2185 OUT.n919 VSS 0.15923f
C2186 OUT.n920 VSS 0.13041f
C2187 OUT.n921 VSS 0.55099f
C2188 OUT.n922 VSS 0.26082f
C2189 OUT.t76 VSS 0.01473f
C2190 OUT.t650 VSS 0.01481f
C2191 OUT.n923 VSS 0.33136f
C2192 OUT.t365 VSS 0.01455f
C2193 OUT.n924 VSS 0.03331f
C2194 OUT.t340 VSS 0.01455f
C2195 OUT.n925 VSS 0.03205f
C2196 OUT.n926 VSS 0.11411f
C2197 OUT.n927 VSS 0.11411f
C2198 OUT.t317 VSS 0.01455f
C2199 OUT.n928 VSS 0.03277f
C2200 OUT.t189 VSS 0.01455f
C2201 OUT.n929 VSS 0.03355f
C2202 OUT.n930 VSS 0.11683f
C2203 OUT.n931 VSS 0.11683f
C2204 OUT.t163 VSS 0.01455f
C2205 OUT.n932 VSS 0.03405f
C2206 OUT.t895 VSS 0.01455f
C2207 OUT.n933 VSS 0.03277f
C2208 OUT.n934 VSS 0.11411f
C2209 OUT.n935 VSS 0.11411f
C2210 OUT.t871 VSS 0.01455f
C2211 OUT.n936 VSS 0.03226f
C2212 OUT.t182 VSS 0.01455f
C2213 OUT.n937 VSS 0.03277f
C2214 OUT.n938 VSS 0.11683f
C2215 OUT.n939 VSS 0.11683f
C2216 OUT.t33 VSS 0.01455f
C2217 OUT.n940 VSS 0.03458f
C2218 OUT.t5 VSS 0.01455f
C2219 OUT.n941 VSS 0.03278f
C2220 OUT.n942 VSS 0.11411f
C2221 OUT.n943 VSS 0.11411f
C2222 OUT.t743 VSS 0.01455f
C2223 OUT.n944 VSS 0.03352f
C2224 OUT.t718 VSS 0.01455f
C2225 OUT.n945 VSS 0.03226f
C2226 OUT.n946 VSS 0.11411f
C2227 OUT.n947 VSS 0.11411f
C2228 OUT.t700 VSS 0.01455f
C2229 OUT.n948 VSS 0.03269f
C2230 OUT.t758 VSS 0.01455f
C2231 OUT.n949 VSS 0.03346f
C2232 OUT.n950 VSS 0.11683f
C2233 OUT.n951 VSS 0.11683f
C2234 OUT.t734 VSS 0.01455f
C2235 OUT.n952 VSS 0.03395f
C2236 OUT.t804 VSS 0.01455f
C2237 OUT.n953 VSS 0.03269f
C2238 OUT.n954 VSS 0.11411f
C2239 OUT.n955 VSS 0.11411f
C2240 OUT.t779 VSS 0.01455f
C2241 OUT.n956 VSS 0.03192f
C2242 OUT.t651 VSS 0.01455f
C2243 OUT.n957 VSS 0.03269f
C2244 OUT.n958 VSS 0.11683f
C2245 OUT.n959 VSS 0.11683f
C2246 OUT.t629 VSS 0.01455f
C2247 OUT.n960 VSS 0.03449f
C2248 OUT.t604 VSS 0.01455f
C2249 OUT.n961 VSS 0.0327f
C2250 OUT.n962 VSS 0.11411f
C2251 OUT.n963 VSS 0.11411f
C2252 OUT.t318 VSS 0.01455f
C2253 OUT.n964 VSS 0.03343f
C2254 OUT.t297 VSS 0.01455f
C2255 OUT.n965 VSS 0.03192f
C2256 OUT.n966 VSS 0.11411f
C2257 OUT.n967 VSS 0.11411f
C2258 OUT.t161 VSS 0.01455f
C2259 OUT.n968 VSS 0.03269f
C2260 OUT.t133 VSS 0.01455f
C2261 OUT.n969 VSS 0.03346f
C2262 OUT.n970 VSS 0.11683f
C2263 OUT.n971 VSS 0.11683f
C2264 OUT.t458 VSS 0.01455f
C2265 OUT.n972 VSS 0.03395f
C2266 OUT.t178 VSS 0.01455f
C2267 OUT.n973 VSS 0.03269f
C2268 OUT.n974 VSS 0.11411f
C2269 OUT.n975 VSS 0.11411f
C2270 OUT.t150 VSS 0.01455f
C2271 OUT.n976 VSS 0.03192f
C2272 OUT.t6 VSS 0.01455f
C2273 OUT.n977 VSS 0.03269f
C2274 OUT.n978 VSS 0.11411f
C2275 OUT.n979 VSS 0.11411f
C2276 OUT.t1008 VSS 0.01455f
C2277 OUT.n980 VSS 0.0327f
C2278 OUT.t984 VSS 0.01455f
C2279 OUT.n981 VSS 0.03398f
C2280 OUT.n982 VSS 0.11683f
C2281 OUT.n983 VSS 0.11683f
C2282 OUT.t697 VSS 0.01455f
C2283 OUT.n984 VSS 0.03343f
C2284 OUT.t679 VSS 0.01455f
C2285 OUT.n985 VSS 0.03192f
C2286 OUT.n986 VSS 0.11411f
C2287 OUT.n987 VSS 0.11411f
C2288 OUT.t883 VSS 0.01455f
C2289 OUT.n988 VSS 0.03269f
C2290 OUT.t857 VSS 0.01455f
C2291 OUT.n989 VSS 0.03346f
C2292 OUT.n990 VSS 0.11683f
C2293 OUT.n991 VSS 0.11683f
C2294 OUT.t835 VSS 0.01455f
C2295 OUT.n992 VSS 0.03395f
C2296 OUT.t564 VSS 0.01455f
C2297 OUT.n993 VSS 0.03269f
C2298 OUT.n994 VSS 0.11411f
C2299 OUT.n995 VSS 0.11411f
C2300 OUT.t424 VSS 0.01455f
C2301 OUT.n996 VSS 0.03192f
C2302 OUT.t397 VSS 0.01455f
C2303 OUT.n997 VSS 0.03269f
C2304 OUT.n998 VSS 0.11411f
C2305 OUT.n999 VSS 0.11411f
C2306 OUT.t374 VSS 0.01455f
C2307 OUT.n1000 VSS 0.0327f
C2308 OUT.t348 VSS 0.01455f
C2309 OUT.n1001 VSS 0.03398f
C2310 OUT.n1002 VSS 0.11411f
C2311 OUT.n1003 VSS 0.11411f
C2312 OUT.t419 VSS 0.01455f
C2313 OUT.n1004 VSS 0.03274f
C2314 OUT.t279 VSS 0.01455f
C2315 OUT.n1005 VSS 0.03504f
C2316 OUT.n1006 VSS 0.11683f
C2317 OUT.n1007 VSS 0.11683f
C2318 OUT.t255 VSS 0.01455f
C2319 OUT.n1008 VSS 0.03269f
C2320 OUT.t233 VSS 0.01455f
C2321 OUT.n1009 VSS 0.03346f
C2322 OUT.n1010 VSS 0.11411f
C2323 OUT.n1011 VSS 0.11411f
C2324 OUT.t209 VSS 0.01455f
C2325 OUT.n1012 VSS 0.03272f
C2326 OUT.t941 VSS 0.01455f
C2327 OUT.n1013 VSS 0.03452f
C2328 OUT.n1014 VSS 0.11683f
C2329 OUT.n1015 VSS 0.11683f
C2330 OUT.t799 VSS 0.01455f
C2331 OUT.n1016 VSS 0.03192f
C2332 OUT.t775 VSS 0.01455f
C2333 OUT.n1017 VSS 0.03269f
C2334 OUT.n1018 VSS 0.11411f
C2335 OUT.n1019 VSS 0.11411f
C2336 OUT.t751 VSS 0.01455f
C2337 OUT.n1020 VSS 0.0327f
C2338 OUT.t61 VSS 0.01455f
C2339 OUT.n1021 VSS 0.03398f
C2340 OUT.n1022 VSS 0.11411f
C2341 OUT.n1023 VSS 0.11411f
C2342 OUT.t686 VSS 0.01455f
C2343 OUT.n1024 VSS 0.03274f
C2344 OUT.t666 VSS 0.01455f
C2345 OUT.n1025 VSS 0.03504f
C2346 OUT.n1026 VSS 0.11683f
C2347 OUT.n1027 VSS 0.11683f
C2348 OUT.t645 VSS 0.01455f
C2349 OUT.n1028 VSS 0.03269f
C2350 OUT.t623 VSS 0.01455f
C2351 OUT.n1029 VSS 0.03346f
C2352 OUT.n1030 VSS 0.11683f
C2353 OUT.n1031 VSS 0.11683f
C2354 OUT.t596 VSS 0.01455f
C2355 OUT.n1032 VSS 0.03395f
C2356 OUT.t115 VSS 0.01455f
C2357 OUT.n1033 VSS 0.03269f
C2358 OUT.n1034 VSS 0.11411f
C2359 OUT.n1035 VSS 0.11411f
C2360 OUT.t91 VSS 0.01455f
C2361 OUT.n1036 VSS 0.03192f
C2362 OUT.t422 VSS 0.01455f
C2363 OUT.n1037 VSS 0.03269f
C2364 OUT.n1038 VSS 0.11411f
C2365 OUT.n1039 VSS 0.11411f
C2366 OUT.t391 VSS 0.01455f
C2367 OUT.n1040 VSS 0.0327f
C2368 OUT.t1020 VSS 0.01455f
C2369 OUT.n1041 VSS 0.03398f
C2370 OUT.n1042 VSS 0.11683f
C2371 OUT.n1043 VSS 0.11683f
C2372 OUT.t29 VSS 0.01455f
C2373 OUT.n1044 VSS 0.03343f
C2374 OUT.t56 VSS 0.01455f
C2375 OUT.n1045 VSS 0.03192f
C2376 OUT.n1046 VSS 0.12616f
C2377 OUT.n1047 VSS 0.1934f
C2378 OUT.n1048 VSS 0.13041f
C2379 OUT.n1049 VSS 0.55099f
C2380 OUT.n1050 VSS 0.15867f
C2381 OUT.t903 VSS 0.01473f
C2382 OUT.t453 VSS 0.01481f
C2383 OUT.n1051 VSS 0.33145f
C2384 OUT.t177 VSS 0.01455f
C2385 OUT.n1052 VSS 0.03189f
C2386 OUT.t149 VSS 0.01455f
C2387 OUT.n1053 VSS 0.03242f
C2388 OUT.n1054 VSS 0.11411f
C2389 OUT.n1055 VSS 0.11411f
C2390 OUT.t124 VSS 0.01455f
C2391 OUT.n1056 VSS 0.03264f
C2392 OUT.t1003 VSS 0.01455f
C2393 OUT.n1057 VSS 0.0321f
C2394 OUT.n1058 VSS 0.11683f
C2395 OUT.n1059 VSS 0.11683f
C2396 OUT.t979 VSS 0.01455f
C2397 OUT.n1060 VSS 0.03157f
C2398 OUT.t696 VSS 0.01455f
C2399 OUT.n1061 VSS 0.03264f
C2400 OUT.n1062 VSS 0.11411f
C2401 OUT.n1063 VSS 0.11411f
C2402 OUT.t678 VSS 0.01455f
C2403 OUT.n1064 VSS 0.03264f
C2404 OUT.t999 VSS 0.01455f
C2405 OUT.n1065 VSS 0.03264f
C2406 OUT.n1066 VSS 0.11683f
C2407 OUT.n1067 VSS 0.11683f
C2408 OUT.t856 VSS 0.01455f
C2409 OUT.n1068 VSS 0.03104f
C2410 OUT.t834 VSS 0.01455f
C2411 OUT.n1069 VSS 0.03264f
C2412 OUT.n1070 VSS 0.11411f
C2413 OUT.n1071 VSS 0.11411f
C2414 OUT.t562 VSS 0.01455f
C2415 OUT.n1072 VSS 0.0321f
C2416 OUT.t539 VSS 0.01455f
C2417 OUT.n1073 VSS 0.03264f
C2418 OUT.n1074 VSS 0.11411f
C2419 OUT.n1075 VSS 0.11411f
C2420 OUT.t516 VSS 0.01455f
C2421 OUT.n1076 VSS 0.03242f
C2422 OUT.t580 VSS 0.01455f
C2423 OUT.n1077 VSS 0.03189f
C2424 OUT.n1078 VSS 0.11683f
C2425 OUT.n1079 VSS 0.11683f
C2426 OUT.t555 VSS 0.01455f
C2427 OUT.n1080 VSS 0.03136f
C2428 OUT.t622 VSS 0.01455f
C2429 OUT.n1081 VSS 0.03242f
C2430 OUT.n1082 VSS 0.11411f
C2431 OUT.n1083 VSS 0.11411f
C2432 OUT.t593 VSS 0.01455f
C2433 OUT.n1084 VSS 0.03242f
C2434 OUT.t451 VSS 0.01455f
C2435 OUT.n1085 VSS 0.03242f
C2436 OUT.n1086 VSS 0.11683f
C2437 OUT.n1087 VSS 0.11683f
C2438 OUT.t434 VSS 0.01455f
C2439 OUT.n1088 VSS 0.03082f
C2440 OUT.t404 VSS 0.01455f
C2441 OUT.n1089 VSS 0.03242f
C2442 OUT.n1090 VSS 0.11411f
C2443 OUT.n1091 VSS 0.11411f
C2444 OUT.t122 VSS 0.01455f
C2445 OUT.n1092 VSS 0.03189f
C2446 OUT.t99 VSS 0.01455f
C2447 OUT.n1093 VSS 0.03242f
C2448 OUT.n1094 VSS 0.11411f
C2449 OUT.n1095 VSS 0.11411f
C2450 OUT.t980 VSS 0.01455f
C2451 OUT.n1096 VSS 0.03242f
C2452 OUT.t958 VSS 0.01455f
C2453 OUT.n1097 VSS 0.03189f
C2454 OUT.n1098 VSS 0.11683f
C2455 OUT.n1099 VSS 0.11683f
C2456 OUT.t259 VSS 0.01455f
C2457 OUT.n1100 VSS 0.03136f
C2458 OUT.t1000 VSS 0.01455f
C2459 OUT.n1101 VSS 0.03242f
C2460 OUT.n1102 VSS 0.11411f
C2461 OUT.n1103 VSS 0.11411f
C2462 OUT.t972 VSS 0.01455f
C2463 OUT.n1104 VSS 0.03242f
C2464 OUT.t832 VSS 0.01455f
C2465 OUT.n1105 VSS 0.03242f
C2466 OUT.n1106 VSS 0.11411f
C2467 OUT.n1107 VSS 0.11411f
C2468 OUT.t807 VSS 0.01455f
C2469 OUT.n1108 VSS 0.03242f
C2470 OUT.t783 VSS 0.01455f
C2471 OUT.n1109 VSS 0.03136f
C2472 OUT.n1110 VSS 0.11683f
C2473 OUT.n1111 VSS 0.11683f
C2474 OUT.t517 VSS 0.01455f
C2475 OUT.n1112 VSS 0.03189f
C2476 OUT.t491 VSS 0.01455f
C2477 OUT.n1113 VSS 0.03242f
C2478 OUT.n1114 VSS 0.11411f
C2479 OUT.n1115 VSS 0.11411f
C2480 OUT.t692 VSS 0.01455f
C2481 OUT.n1116 VSS 0.03242f
C2482 OUT.t669 VSS 0.01455f
C2483 OUT.n1117 VSS 0.03189f
C2484 OUT.n1118 VSS 0.11683f
C2485 OUT.n1119 VSS 0.11683f
C2486 OUT.t649 VSS 0.01455f
C2487 OUT.n1120 VSS 0.03136f
C2488 OUT.t363 VSS 0.01455f
C2489 OUT.n1121 VSS 0.03242f
C2490 OUT.n1122 VSS 0.11411f
C2491 OUT.n1123 VSS 0.11411f
C2492 OUT.t231 VSS 0.01455f
C2493 OUT.n1124 VSS 0.03242f
C2494 OUT.t208 VSS 0.01455f
C2495 OUT.n1125 VSS 0.03242f
C2496 OUT.n1126 VSS 0.11411f
C2497 OUT.n1127 VSS 0.11411f
C2498 OUT.t188 VSS 0.01455f
C2499 OUT.n1128 VSS 0.03242f
C2500 OUT.t160 VSS 0.01455f
C2501 OUT.n1129 VSS 0.03136f
C2502 OUT.n1130 VSS 0.11411f
C2503 OUT.n1131 VSS 0.11411f
C2504 OUT.t226 VSS 0.01455f
C2505 OUT.n1132 VSS 0.03242f
C2506 OUT.t78 VSS 0.01455f
C2507 OUT.n1133 VSS 0.03029f
C2508 OUT.n1134 VSS 0.11683f
C2509 OUT.n1135 VSS 0.11683f
C2510 OUT.t59 VSS 0.01455f
C2511 OUT.n1136 VSS 0.03242f
C2512 OUT.t31 VSS 0.01455f
C2513 OUT.n1137 VSS 0.03189f
C2514 OUT.n1138 VSS 0.11411f
C2515 OUT.n1139 VSS 0.11411f
C2516 OUT.t4 VSS 0.01455f
C2517 OUT.n1140 VSS 0.03242f
C2518 OUT.t741 VSS 0.01455f
C2519 OUT.n1141 VSS 0.03082f
C2520 OUT.n1142 VSS 0.11683f
C2521 OUT.n1143 VSS 0.11683f
C2522 OUT.t618 VSS 0.01455f
C2523 OUT.n1144 VSS 0.03242f
C2524 OUT.t590 VSS 0.01455f
C2525 OUT.n1145 VSS 0.03242f
C2526 OUT.n1146 VSS 0.11411f
C2527 OUT.n1147 VSS 0.11411f
C2528 OUT.t568 VSS 0.01455f
C2529 OUT.n1148 VSS 0.03242f
C2530 OUT.t882 VSS 0.01455f
C2531 OUT.n1149 VSS 0.03136f
C2532 OUT.n1150 VSS 0.11411f
C2533 OUT.n1151 VSS 0.11411f
C2534 OUT.t499 VSS 0.01455f
C2535 OUT.n1152 VSS 0.03242f
C2536 OUT.t473 VSS 0.01455f
C2537 OUT.n1153 VSS 0.03029f
C2538 OUT.n1154 VSS 0.11683f
C2539 OUT.n1155 VSS 0.11683f
C2540 OUT.t445 VSS 0.01455f
C2541 OUT.n1156 VSS 0.03242f
C2542 OUT.t423 VSS 0.01455f
C2543 OUT.n1157 VSS 0.03189f
C2544 OUT.n1158 VSS 0.11683f
C2545 OUT.n1159 VSS 0.11683f
C2546 OUT.t396 VSS 0.01455f
C2547 OUT.n1160 VSS 0.03136f
C2548 OUT.t940 VSS 0.01455f
C2549 OUT.n1161 VSS 0.03242f
C2550 OUT.n1162 VSS 0.11411f
C2551 OUT.n1163 VSS 0.11411f
C2552 OUT.t920 VSS 0.01455f
C2553 OUT.n1164 VSS 0.03242f
C2554 OUT.t227 VSS 0.01455f
C2555 OUT.n1165 VSS 0.03242f
C2556 OUT.n1166 VSS 0.11411f
C2557 OUT.n1167 VSS 0.11411f
C2558 OUT.t205 VSS 0.01455f
C2559 OUT.n1168 VSS 0.03242f
C2560 OUT.t817 VSS 0.01455f
C2561 OUT.n1169 VSS 0.03136f
C2562 OUT.n1170 VSS 0.11683f
C2563 OUT.n1171 VSS 0.11683f
C2564 OUT.t853 VSS 0.01455f
C2565 OUT.n1172 VSS 0.03189f
C2566 OUT.t879 VSS 0.01455f
C2567 OUT.n1173 VSS 0.03242f
C2568 OUT.n1174 VSS 0.12616f
C2569 OUT.n1175 VSS 0.1935f
C2570 OUT.n1176 VSS 0.2217f
C2571 OUT.n1177 VSS 0.55099f
C2572 OUT.n1178 VSS 0.13041f
C2573 OUT.t322 VSS 0.01473f
C2574 OUT.t995 VSS 0.01481f
C2575 OUT.n1179 VSS 0.33124f
C2576 OUT.t956 VSS 0.01455f
C2577 OUT.n1180 VSS 0.03331f
C2578 OUT.t660 VSS 0.01455f
C2579 OUT.n1181 VSS 0.03205f
C2580 OUT.n1182 VSS 0.11411f
C2581 OUT.n1183 VSS 0.11411f
C2582 OUT.t350 VSS 0.01455f
C2583 OUT.n1184 VSS 0.03277f
C2584 OUT.t395 VSS 0.01455f
C2585 OUT.n1185 VSS 0.0333f
C2586 OUT.n1186 VSS 0.11683f
C2587 OUT.n1187 VSS 0.11683f
C2588 OUT.t89 VSS 0.01455f
C2589 OUT.n1188 VSS 0.03406f
C2590 OUT.t53 VSS 0.01455f
C2591 OUT.n1189 VSS 0.03277f
C2592 OUT.n1190 VSS 0.11411f
C2593 OUT.n1191 VSS 0.11411f
C2594 OUT.t763 VSS 0.01455f
C2595 OUT.n1192 VSS 0.03277f
C2596 OUT.t218 VSS 0.01455f
C2597 OUT.n1193 VSS 0.03277f
C2598 OUT.n1194 VSS 0.11683f
C2599 OUT.n1195 VSS 0.11683f
C2600 OUT.t254 VSS 0.01455f
C2601 OUT.n1196 VSS 0.03459f
C2602 OUT.t964 VSS 0.01455f
C2603 OUT.n1197 VSS 0.03278f
C2604 OUT.n1198 VSS 0.11411f
C2605 OUT.n1199 VSS 0.11411f
C2606 OUT.t933 VSS 0.01455f
C2607 OUT.n1200 VSS 0.03352f
C2608 OUT.t637 VSS 0.01455f
C2609 OUT.n1201 VSS 0.03226f
C2610 OUT.n1202 VSS 0.11411f
C2611 OUT.n1203 VSS 0.11411f
C2612 OUT.t325 VSS 0.01455f
C2613 OUT.n1204 VSS 0.03256f
C2614 OUT.t185 VSS 0.01455f
C2615 OUT.n1205 VSS 0.03309f
C2616 OUT.n1206 VSS 0.11683f
C2617 OUT.n1207 VSS 0.11683f
C2618 OUT.t891 VSS 0.01455f
C2619 OUT.n1208 VSS 0.03384f
C2620 OUT.t605 VSS 0.01455f
C2621 OUT.n1209 VSS 0.03256f
C2622 OUT.n1210 VSS 0.11411f
C2623 OUT.n1211 VSS 0.11411f
C2624 OUT.t298 VSS 0.01455f
C2625 OUT.n1212 VSS 0.03255f
C2626 OUT.t338 VSS 0.01455f
C2627 OUT.n1213 VSS 0.03256f
C2628 OUT.n1214 VSS 0.11683f
C2629 OUT.n1215 VSS 0.11683f
C2630 OUT.t36 VSS 0.01455f
C2631 OUT.n1216 VSS 0.03438f
C2632 OUT.t746 VSS 0.01455f
C2633 OUT.n1217 VSS 0.03257f
C2634 OUT.n1218 VSS 0.11411f
C2635 OUT.n1219 VSS 0.11411f
C2636 OUT.t710 VSS 0.01455f
C2637 OUT.n1220 VSS 0.03331f
C2638 OUT.t416 VSS 0.01455f
C2639 OUT.n1221 VSS 0.03205f
C2640 OUT.n1222 VSS 0.11411f
C2641 OUT.n1223 VSS 0.11411f
C2642 OUT.t461 VSS 0.01455f
C2643 OUT.n1224 VSS 0.03256f
C2644 OUT.t157 VSS 0.01455f
C2645 OUT.n1225 VSS 0.03309f
C2646 OUT.n1226 VSS 0.11683f
C2647 OUT.n1227 VSS 0.11683f
C2648 OUT.t621 VSS 0.01455f
C2649 OUT.n1228 VSS 0.03384f
C2650 OUT.t582 VSS 0.01455f
C2651 OUT.n1229 VSS 0.03256f
C2652 OUT.n1230 VSS 0.11411f
C2653 OUT.n1231 VSS 0.11411f
C2654 OUT.t277 VSS 0.01455f
C2655 OUT.n1232 VSS 0.03255f
C2656 OUT.t314 VSS 0.01455f
C2657 OUT.n1233 VSS 0.03256f
C2658 OUT.n1234 VSS 0.11411f
C2659 OUT.n1235 VSS 0.11411f
C2660 OUT.t9 VSS 0.01455f
C2661 OUT.n1236 VSS 0.03257f
C2662 OUT.t721 VSS 0.01455f
C2663 OUT.n1237 VSS 0.03362f
C2664 OUT.n1238 VSS 0.11683f
C2665 OUT.n1239 VSS 0.11683f
C2666 OUT.t691 VSS 0.01455f
C2667 OUT.n1240 VSS 0.03331f
C2668 OUT.t389 VSS 0.01455f
C2669 OUT.n1241 VSS 0.03205f
C2670 OUT.n1242 VSS 0.11411f
C2671 OUT.n1243 VSS 0.11411f
C2672 OUT.t186 VSS 0.01455f
C2673 OUT.n1244 VSS 0.03256f
C2674 OUT.t892 VSS 0.01455f
C2675 OUT.n1245 VSS 0.03309f
C2676 OUT.n1246 VSS 0.11683f
C2677 OUT.n1247 VSS 0.11683f
C2678 OUT.t595 VSS 0.01455f
C2679 OUT.n1248 VSS 0.03384f
C2680 OUT.t559 VSS 0.01455f
C2681 OUT.n1249 VSS 0.03256f
C2682 OUT.n1250 VSS 0.11411f
C2683 OUT.n1251 VSS 0.11411f
C2684 OUT.t601 VSS 0.01455f
C2685 OUT.n1252 VSS 0.03255f
C2686 OUT.t292 VSS 0.01455f
C2687 OUT.n1253 VSS 0.03256f
C2688 OUT.n1254 VSS 0.11411f
C2689 OUT.n1255 VSS 0.11411f
C2690 OUT.t1012 VSS 0.01455f
C2691 OUT.n1256 VSS 0.03257f
C2692 OUT.t701 VSS 0.01455f
C2693 OUT.n1257 VSS 0.03362f
C2694 OUT.n1258 VSS 0.11411f
C2695 OUT.n1259 VSS 0.11411f
C2696 OUT.t417 VSS 0.01455f
C2697 OUT.n1260 VSS 0.0326f
C2698 OUT.t462 VSS 0.01455f
C2699 OUT.n1261 VSS 0.03469f
C2700 OUT.n1262 VSS 0.11683f
C2701 OUT.n1263 VSS 0.11683f
C2702 OUT.t158 VSS 0.01455f
C2703 OUT.n1264 VSS 0.03256f
C2704 OUT.t867 VSS 0.01455f
C2705 OUT.n1265 VSS 0.03309f
C2706 OUT.n1266 VSS 0.11411f
C2707 OUT.n1267 VSS 0.11411f
C2708 OUT.t572 VSS 0.01455f
C2709 OUT.n1268 VSS 0.03258f
C2710 OUT.t530 VSS 0.01455f
C2711 OUT.n1269 VSS 0.03415f
C2712 OUT.n1270 VSS 0.11683f
C2713 OUT.n1271 VSS 0.11683f
C2714 OUT.t579 VSS 0.01455f
C2715 OUT.n1272 VSS 0.03255f
C2716 OUT.t273 VSS 0.01455f
C2717 OUT.n1273 VSS 0.03256f
C2718 OUT.n1274 VSS 0.11411f
C2719 OUT.n1275 VSS 0.11411f
C2720 OUT.t987 VSS 0.01455f
C2721 OUT.n1276 VSS 0.03257f
C2722 OUT.t431 VSS 0.01455f
C2723 OUT.n1277 VSS 0.03362f
C2724 OUT.n1278 VSS 0.11411f
C2725 OUT.n1279 VSS 0.11411f
C2726 OUT.t727 VSS 0.01455f
C2727 OUT.n1280 VSS 0.0326f
C2728 OUT.t438 VSS 0.01455f
C2729 OUT.n1281 VSS 0.03469f
C2730 OUT.n1282 VSS 0.11683f
C2731 OUT.n1283 VSS 0.11683f
C2732 OUT.t131 VSS 0.01455f
C2733 OUT.n1284 VSS 0.03256f
C2734 OUT.t842 VSS 0.01455f
C2735 OUT.n1285 VSS 0.03309f
C2736 OUT.n1286 VSS 0.11683f
C2737 OUT.n1287 VSS 0.11683f
C2738 OUT.t549 VSS 0.01455f
C2739 OUT.n1288 VSS 0.03384f
C2740 OUT.t482 VSS 0.01455f
C2741 OUT.n1289 VSS 0.03256f
C2742 OUT.n1290 VSS 0.11411f
C2743 OUT.n1291 VSS 0.11411f
C2744 OUT.t176 VSS 0.01455f
C2745 OUT.n1292 VSS 0.03255f
C2746 OUT.t644 VSS 0.01455f
C2747 OUT.n1293 VSS 0.03256f
C2748 OUT.n1294 VSS 0.11411f
C2749 OUT.n1295 VSS 0.11411f
C2750 OUT.t333 VSS 0.01455f
C2751 OUT.n1296 VSS 0.03257f
C2752 OUT.t373 VSS 0.01455f
C2753 OUT.n1297 VSS 0.03362f
C2754 OUT.n1298 VSS 0.11683f
C2755 OUT.n1299 VSS 0.11683f
C2756 OUT.t731 VSS 0.01455f
C2757 OUT.n1300 VSS 0.03331f
C2758 OUT.t18 VSS 0.01455f
C2759 OUT.n1301 VSS 0.03205f
C2760 OUT.n1302 VSS 0.12616f
C2761 OUT.n1303 VSS 0.19327f
C2762 OUT.n1304 VSS 0.19618f
C2763 OUT.n1305 VSS 0.1804f
C2764 OUT.n1306 VSS 0.55099f
C2765 OUT.n1307 VSS 0.55099f
C2766 OUT.n1308 VSS 0.21083f
C2767 OUT.t901 VSS 0.01473f
C2768 OUT.t560 VSS 0.01481f
C2769 OUT.n1309 VSS 0.33133f
C2770 OUT.t525 VSS 0.01455f
C2771 OUT.n1310 VSS 0.03307f
C2772 OUT.t221 VSS 0.01455f
C2773 OUT.n1311 VSS 0.0323f
C2774 OUT.n1312 VSS 0.11411f
C2775 OUT.n1313 VSS 0.11411f
C2776 OUT.t932 VSS 0.01455f
C2777 OUT.n1314 VSS 0.03251f
C2778 OUT.t969 VSS 0.01455f
C2779 OUT.n1315 VSS 0.03329f
C2780 OUT.n1316 VSS 0.11683f
C2781 OUT.n1317 VSS 0.11683f
C2782 OUT.t670 VSS 0.01455f
C2783 OUT.n1318 VSS 0.03381f
C2784 OUT.t642 VSS 0.01455f
C2785 OUT.n1319 VSS 0.03251f
C2786 OUT.n1320 VSS 0.11411f
C2787 OUT.n1321 VSS 0.11411f
C2788 OUT.t332 VSS 0.01455f
C2789 OUT.n1322 VSS 0.03251f
C2790 OUT.t787 VSS 0.01455f
C2791 OUT.n1323 VSS 0.03251f
C2792 OUT.n1324 VSS 0.11683f
C2793 OUT.n1325 VSS 0.11683f
C2794 OUT.t830 VSS 0.01455f
C2795 OUT.n1326 VSS 0.03434f
C2796 OUT.t537 VSS 0.01455f
C2797 OUT.n1327 VSS 0.03251f
C2798 OUT.n1328 VSS 0.11411f
C2799 OUT.n1329 VSS 0.11411f
C2800 OUT.t501 VSS 0.01455f
C2801 OUT.n1330 VSS 0.03329f
C2802 OUT.t200 VSS 0.01455f
C2803 OUT.n1331 VSS 0.03251f
C2804 OUT.n1332 VSS 0.11411f
C2805 OUT.n1333 VSS 0.11411f
C2806 OUT.t904 VSS 0.01455f
C2807 OUT.n1334 VSS 0.03242f
C2808 OUT.t750 VSS 0.01455f
C2809 OUT.n1335 VSS 0.0332f
C2810 OUT.n1336 VSS 0.11683f
C2811 OUT.n1337 VSS 0.11683f
C2812 OUT.t460 VSS 0.01455f
C2813 OUT.n1338 VSS 0.03371f
C2814 OUT.t166 VSS 0.01455f
C2815 OUT.n1339 VSS 0.03242f
C2816 OUT.n1340 VSS 0.11411f
C2817 OUT.n1341 VSS 0.11411f
C2818 OUT.t878 VSS 0.01455f
C2819 OUT.n1342 VSS 0.03217f
C2820 OUT.t919 VSS 0.01455f
C2821 OUT.n1343 VSS 0.03242f
C2822 OUT.n1344 VSS 0.11683f
C2823 OUT.n1345 VSS 0.11683f
C2824 OUT.t626 VSS 0.01455f
C2825 OUT.n1346 VSS 0.03425f
C2826 OUT.t312 VSS 0.01455f
C2827 OUT.n1347 VSS 0.03243f
C2828 OUT.n1348 VSS 0.11411f
C2829 OUT.n1349 VSS 0.11411f
C2830 OUT.t278 VSS 0.01455f
C2831 OUT.n1350 VSS 0.03319f
C2832 OUT.t993 VSS 0.01455f
C2833 OUT.n1351 VSS 0.03217f
C2834 OUT.n1352 VSS 0.11411f
C2835 OUT.n1353 VSS 0.11411f
C2836 OUT.t14 VSS 0.01455f
C2837 OUT.n1354 VSS 0.03242f
C2838 OUT.t726 VSS 0.01455f
C2839 OUT.n1355 VSS 0.0332f
C2840 OUT.n1356 VSS 0.11683f
C2841 OUT.n1357 VSS 0.11683f
C2842 OUT.t181 VSS 0.01455f
C2843 OUT.n1358 VSS 0.03371f
C2844 OUT.t140 VSS 0.01455f
C2845 OUT.n1359 VSS 0.03242f
C2846 OUT.n1360 VSS 0.11411f
C2847 OUT.n1361 VSS 0.11411f
C2848 OUT.t851 VSS 0.01455f
C2849 OUT.n1362 VSS 0.03217f
C2850 OUT.t894 VSS 0.01455f
C2851 OUT.n1363 VSS 0.03242f
C2852 OUT.n1364 VSS 0.11411f
C2853 OUT.n1365 VSS 0.11411f
C2854 OUT.t599 VSS 0.01455f
C2855 OUT.n1366 VSS 0.03243f
C2856 OUT.t288 VSS 0.01455f
C2857 OUT.n1367 VSS 0.03372f
C2858 OUT.n1368 VSS 0.11683f
C2859 OUT.n1369 VSS 0.11683f
C2860 OUT.t253 VSS 0.01455f
C2861 OUT.n1370 VSS 0.03319f
C2862 OUT.t963 VSS 0.01455f
C2863 OUT.n1371 VSS 0.03217f
C2864 OUT.n1372 VSS 0.11411f
C2865 OUT.n1373 VSS 0.11411f
C2866 OUT.t748 VSS 0.01455f
C2867 OUT.n1374 VSS 0.03242f
C2868 OUT.t457 VSS 0.01455f
C2869 OUT.n1375 VSS 0.0332f
C2870 OUT.n1376 VSS 0.11683f
C2871 OUT.n1377 VSS 0.11683f
C2872 OUT.t153 VSS 0.01455f
C2873 OUT.n1378 VSS 0.03371f
C2874 OUT.t112 VSS 0.01455f
C2875 OUT.n1379 VSS 0.03242f
C2876 OUT.n1380 VSS 0.11411f
C2877 OUT.n1381 VSS 0.11411f
C2878 OUT.t159 VSS 0.01455f
C2879 OUT.n1382 VSS 0.03217f
C2880 OUT.t870 VSS 0.01455f
C2881 OUT.n1383 VSS 0.03242f
C2882 OUT.n1384 VSS 0.11411f
C2883 OUT.n1385 VSS 0.11411f
C2884 OUT.t576 VSS 0.01455f
C2885 OUT.n1386 VSS 0.03243f
C2886 OUT.t268 VSS 0.01455f
C2887 OUT.n1387 VSS 0.03372f
C2888 OUT.n1388 VSS 0.11411f
C2889 OUT.n1389 VSS 0.11411f
C2890 OUT.t994 VSS 0.01455f
C2891 OUT.n1390 VSS 0.03244f
C2892 OUT.t11 VSS 0.01455f
C2893 OUT.n1391 VSS 0.03478f
C2894 OUT.n1392 VSS 0.11683f
C2895 OUT.n1393 VSS 0.11683f
C2896 OUT.t724 VSS 0.01455f
C2897 OUT.n1394 VSS 0.03242f
C2898 OUT.t437 VSS 0.01455f
C2899 OUT.n1395 VSS 0.0332f
C2900 OUT.n1396 VSS 0.11411f
C2901 OUT.n1397 VSS 0.11411f
C2902 OUT.t126 VSS 0.01455f
C2903 OUT.n1398 VSS 0.03244f
C2904 OUT.t82 VSS 0.01455f
C2905 OUT.n1399 VSS 0.03426f
C2906 OUT.n1400 VSS 0.11683f
C2907 OUT.n1401 VSS 0.11683f
C2908 OUT.t135 VSS 0.01455f
C2909 OUT.n1402 VSS 0.03217f
C2910 OUT.t846 VSS 0.01455f
C2911 OUT.n1403 VSS 0.03242f
C2912 OUT.n1404 VSS 0.11411f
C2913 OUT.n1405 VSS 0.11411f
C2914 OUT.t554 VSS 0.01455f
C2915 OUT.n1406 VSS 0.03243f
C2916 OUT.t1007 VSS 0.01455f
C2917 OUT.n1407 VSS 0.03372f
C2918 OUT.n1408 VSS 0.11411f
C2919 OUT.n1409 VSS 0.11411f
C2920 OUT.t296 VSS 0.01455f
C2921 OUT.n1410 VSS 0.03244f
C2922 OUT.t1016 VSS 0.01455f
C2923 OUT.n1411 VSS 0.03478f
C2924 OUT.n1412 VSS 0.11683f
C2925 OUT.n1413 VSS 0.11683f
C2926 OUT.t706 VSS 0.01455f
C2927 OUT.n1414 VSS 0.03242f
C2928 OUT.t409 VSS 0.01455f
C2929 OUT.n1415 VSS 0.0332f
C2930 OUT.n1416 VSS 0.11683f
C2931 OUT.n1417 VSS 0.11683f
C2932 OUT.t103 VSS 0.01455f
C2933 OUT.n1418 VSS 0.03371f
C2934 OUT.t35 VSS 0.01455f
C2935 OUT.n1419 VSS 0.03242f
C2936 OUT.n1420 VSS 0.11411f
C2937 OUT.n1421 VSS 0.11411f
C2938 OUT.t745 VSS 0.01455f
C2939 OUT.n1422 VSS 0.03217f
C2940 OUT.t204 VSS 0.01455f
C2941 OUT.n1423 VSS 0.03242f
C2942 OUT.n1424 VSS 0.11411f
C2943 OUT.n1425 VSS 0.11411f
C2944 OUT.t912 VSS 0.01455f
C2945 OUT.n1426 VSS 0.03243f
C2946 OUT.t952 VSS 0.01455f
C2947 OUT.n1427 VSS 0.03372f
C2948 OUT.n1428 VSS 0.11683f
C2949 OUT.n1429 VSS 0.11683f
C2950 OUT.t299 VSS 0.01455f
C2951 OUT.n1430 VSS 0.03319f
C2952 OUT.t607 VSS 0.01455f
C2953 OUT.n1431 VSS 0.03217f
C2954 OUT.n1432 VSS 0.12616f
C2955 OUT.n1433 VSS 0.19338f
C2956 OUT.n1434 VSS 0.13041f
C2957 OUT.n1435 VSS 0.55099f
C2958 OUT.n1436 VSS 0.22387f
C2959 OUT.t408 VSS 0.01473f
C2960 OUT.t58 VSS 0.01481f
C2961 OUT.n1437 VSS 0.33121f
C2962 OUT.t16 VSS 0.01455f
C2963 OUT.n1438 VSS 0.03307f
C2964 OUT.t728 VSS 0.01455f
C2965 OUT.n1439 VSS 0.0323f
C2966 OUT.n1440 VSS 0.11411f
C2967 OUT.n1441 VSS 0.11411f
C2968 OUT.t439 VSS 0.01455f
C2969 OUT.n1442 VSS 0.03251f
C2970 OUT.t481 VSS 0.01455f
C2971 OUT.n1443 VSS 0.03198f
C2972 OUT.n1444 VSS 0.11683f
C2973 OUT.n1445 VSS 0.11683f
C2974 OUT.t175 VSS 0.01455f
C2975 OUT.n1446 VSS 0.03145f
C2976 OUT.t138 VSS 0.01455f
C2977 OUT.n1447 VSS 0.03251f
C2978 OUT.n1448 VSS 0.11411f
C2979 OUT.n1449 VSS 0.11411f
C2980 OUT.t849 VSS 0.01455f
C2981 OUT.n1450 VSS 0.03251f
C2982 OUT.t295 VSS 0.01455f
C2983 OUT.n1451 VSS 0.03251f
C2984 OUT.n1452 VSS 0.11683f
C2985 OUT.n1453 VSS 0.11683f
C2986 OUT.t335 VSS 0.01455f
C2987 OUT.n1454 VSS 0.03092f
C2988 OUT.t30 VSS 0.01455f
C2989 OUT.n1455 VSS 0.03251f
C2990 OUT.n1456 VSS 0.11411f
C2991 OUT.n1457 VSS 0.11411f
C2992 OUT.t1019 VSS 0.01455f
C2993 OUT.n1458 VSS 0.03198f
C2994 OUT.t707 VSS 0.01455f
C2995 OUT.n1459 VSS 0.03251f
C2996 OUT.n1460 VSS 0.11411f
C2997 OUT.n1461 VSS 0.11411f
C2998 OUT.t412 VSS 0.01455f
C2999 OUT.n1462 VSS 0.0323f
C3000 OUT.t260 VSS 0.01455f
C3001 OUT.n1463 VSS 0.03176f
C3002 OUT.n1464 VSS 0.11683f
C3003 OUT.n1465 VSS 0.11683f
C3004 OUT.t974 VSS 0.01455f
C3005 OUT.n1466 VSS 0.03124f
C3006 OUT.t682 VSS 0.01455f
C3007 OUT.n1467 VSS 0.0323f
C3008 OUT.n1468 VSS 0.11411f
C3009 OUT.n1469 VSS 0.11411f
C3010 OUT.t382 VSS 0.01455f
C3011 OUT.n1470 VSS 0.0323f
C3012 OUT.t427 VSS 0.01455f
C3013 OUT.n1471 VSS 0.0323f
C3014 OUT.n1472 VSS 0.11683f
C3015 OUT.n1473 VSS 0.11683f
C3016 OUT.t117 VSS 0.01455f
C3017 OUT.n1474 VSS 0.0307f
C3018 OUT.t831 VSS 0.01455f
C3019 OUT.n1475 VSS 0.0323f
C3020 OUT.n1476 VSS 0.11411f
C3021 OUT.n1477 VSS 0.11411f
C3022 OUT.t794 VSS 0.01455f
C3023 OUT.n1478 VSS 0.03177f
C3024 OUT.t502 VSS 0.01455f
C3025 OUT.n1479 VSS 0.0323f
C3026 OUT.n1480 VSS 0.11411f
C3027 OUT.n1481 VSS 0.11411f
C3028 OUT.t544 VSS 0.01455f
C3029 OUT.n1482 VSS 0.0323f
C3030 OUT.t240 VSS 0.01455f
C3031 OUT.n1483 VSS 0.03176f
C3032 OUT.n1484 VSS 0.11683f
C3033 OUT.n1485 VSS 0.11683f
C3034 OUT.t694 VSS 0.01455f
C3035 OUT.n1486 VSS 0.03124f
C3036 OUT.t665 VSS 0.01455f
C3037 OUT.n1487 VSS 0.0323f
C3038 OUT.n1488 VSS 0.11411f
C3039 OUT.n1489 VSS 0.11411f
C3040 OUT.t358 VSS 0.01455f
C3041 OUT.n1490 VSS 0.0323f
C3042 OUT.t400 VSS 0.01455f
C3043 OUT.n1491 VSS 0.0323f
C3044 OUT.n1492 VSS 0.11411f
C3045 OUT.n1493 VSS 0.11411f
C3046 OUT.t96 VSS 0.01455f
C3047 OUT.n1494 VSS 0.0323f
C3048 OUT.t808 VSS 0.01455f
C3049 OUT.n1495 VSS 0.03123f
C3050 OUT.n1496 VSS 0.11683f
C3051 OUT.n1497 VSS 0.11683f
C3052 OUT.t769 VSS 0.01455f
C3053 OUT.n1498 VSS 0.03177f
C3054 OUT.t477 VSS 0.01455f
C3055 OUT.n1499 VSS 0.0323f
C3056 OUT.n1500 VSS 0.11411f
C3057 OUT.n1501 VSS 0.11411f
C3058 OUT.t258 VSS 0.01455f
C3059 OUT.n1502 VSS 0.0323f
C3060 OUT.t971 VSS 0.01455f
C3061 OUT.n1503 VSS 0.03176f
C3062 OUT.n1504 VSS 0.11683f
C3063 OUT.n1505 VSS 0.11683f
C3064 OUT.t673 VSS 0.01455f
C3065 OUT.n1506 VSS 0.03124f
C3066 OUT.t643 VSS 0.01455f
C3067 OUT.n1507 VSS 0.0323f
C3068 OUT.n1508 VSS 0.11411f
C3069 OUT.n1509 VSS 0.11411f
C3070 OUT.t677 VSS 0.01455f
C3071 OUT.n1510 VSS 0.0323f
C3072 OUT.t379 VSS 0.01455f
C3073 OUT.n1511 VSS 0.0323f
C3074 OUT.n1512 VSS 0.11411f
C3075 OUT.n1513 VSS 0.11411f
C3076 OUT.t71 VSS 0.01455f
C3077 OUT.n1514 VSS 0.0323f
C3078 OUT.t786 VSS 0.01455f
C3079 OUT.n1515 VSS 0.03123f
C3080 OUT.n1516 VSS 0.11411f
C3081 OUT.n1517 VSS 0.11411f
C3082 OUT.t503 VSS 0.01455f
C3083 OUT.n1518 VSS 0.0323f
C3084 OUT.t541 VSS 0.01455f
C3085 OUT.n1519 VSS 0.03017f
C3086 OUT.n1520 VSS 0.11683f
C3087 OUT.n1521 VSS 0.11683f
C3088 OUT.t238 VSS 0.01455f
C3089 OUT.n1522 VSS 0.0323f
C3090 OUT.t949 VSS 0.01455f
C3091 OUT.n1523 VSS 0.03176f
C3092 OUT.n1524 VSS 0.11411f
C3093 OUT.n1525 VSS 0.11411f
C3094 OUT.t657 VSS 0.01455f
C3095 OUT.n1526 VSS 0.0323f
C3096 OUT.t617 VSS 0.01455f
C3097 OUT.n1527 VSS 0.0307f
C3098 OUT.n1528 VSS 0.11683f
C3099 OUT.n1529 VSS 0.11683f
C3100 OUT.t662 VSS 0.01455f
C3101 OUT.n1530 VSS 0.0323f
C3102 OUT.t354 VSS 0.01455f
C3103 OUT.n1531 VSS 0.0323f
C3104 OUT.n1532 VSS 0.11411f
C3105 OUT.n1533 VSS 0.11411f
C3106 OUT.t49 VSS 0.01455f
C3107 OUT.n1534 VSS 0.0323f
C3108 OUT.t515 VSS 0.01455f
C3109 OUT.n1535 VSS 0.03123f
C3110 OUT.n1536 VSS 0.11411f
C3111 OUT.n1537 VSS 0.11411f
C3112 OUT.t812 VSS 0.01455f
C3113 OUT.n1538 VSS 0.0323f
C3114 OUT.t521 VSS 0.01455f
C3115 OUT.n1539 VSS 0.03017f
C3116 OUT.n1540 VSS 0.11683f
C3117 OUT.n1541 VSS 0.11683f
C3118 OUT.t217 VSS 0.01455f
C3119 OUT.n1542 VSS 0.0323f
C3120 OUT.t929 VSS 0.01455f
C3121 OUT.n1543 VSS 0.03176f
C3122 OUT.n1544 VSS 0.11683f
C3123 OUT.n1545 VSS 0.11683f
C3124 OUT.t633 VSS 0.01455f
C3125 OUT.n1546 VSS 0.03124f
C3126 OUT.t563 VSS 0.01455f
C3127 OUT.n1547 VSS 0.0323f
C3128 OUT.n1548 VSS 0.11411f
C3129 OUT.n1549 VSS 0.11411f
C3130 OUT.t257 VSS 0.01455f
C3131 OUT.n1550 VSS 0.0323f
C3132 OUT.t712 VSS 0.01455f
C3133 OUT.n1551 VSS 0.0323f
C3134 OUT.n1552 VSS 0.11411f
C3135 OUT.n1553 VSS 0.11411f
C3136 OUT.t421 VSS 0.01455f
C3137 OUT.n1554 VSS 0.0323f
C3138 OUT.t459 VSS 0.01455f
C3139 OUT.n1555 VSS 0.03123f
C3140 OUT.n1556 VSS 0.11683f
C3141 OUT.n1557 VSS 0.11683f
C3142 OUT.t816 VSS 0.01455f
C3143 OUT.n1558 VSS 0.03177f
C3144 OUT.t102 VSS 0.01455f
C3145 OUT.n1559 VSS 0.0323f
C3146 OUT.n1560 VSS 0.12616f
C3147 OUT.n1561 VSS 0.19326f
C3148 OUT.n1562 VSS 0.17823f
C3149 OUT.n1563 VSS 0.55099f
C3150 OUT.n1564 VSS 0.13041f
C3151 OUT.t977 VSS 0.01473f
C3152 OUT.t639 VSS 0.01481f
C3153 OUT.n1565 VSS 0.33127f
C3154 OUT.t598 VSS 0.01455f
C3155 OUT.n1566 VSS 0.03355f
C3156 OUT.t286 VSS 0.01455f
C3157 OUT.n1567 VSS 0.0318f
C3158 OUT.n1568 VSS 0.11411f
C3159 OUT.n1569 VSS 0.11411f
C3160 OUT.t1004 VSS 0.01455f
C3161 OUT.n1570 VSS 0.03304f
C3162 OUT.t25 VSS 0.01455f
C3163 OUT.n1571 VSS 0.03356f
C3164 OUT.n1572 VSS 0.11683f
C3165 OUT.n1573 VSS 0.11683f
C3166 OUT.t737 VSS 0.01455f
C3167 OUT.n1574 VSS 0.0343f
C3168 OUT.t705 VSS 0.01455f
C3169 OUT.n1575 VSS 0.03303f
C3170 OUT.n1576 VSS 0.11411f
C3171 OUT.n1577 VSS 0.11411f
C3172 OUT.t407 VSS 0.01455f
C3173 OUT.n1578 VSS 0.03302f
C3174 OUT.t860 VSS 0.01455f
C3175 OUT.n1579 VSS 0.03303f
C3176 OUT.n1580 VSS 0.11683f
C3177 OUT.n1581 VSS 0.11683f
C3178 OUT.t906 VSS 0.01455f
C3179 OUT.n1582 VSS 0.03483f
C3180 OUT.t612 VSS 0.01455f
C3181 OUT.n1583 VSS 0.03305f
C3182 OUT.n1584 VSS 0.11411f
C3183 OUT.n1585 VSS 0.11411f
C3184 OUT.t575 VSS 0.01455f
C3185 OUT.n1586 VSS 0.03376f
C3186 OUT.t267 VSS 0.01455f
C3187 OUT.n1587 VSS 0.03201f
C3188 OUT.n1588 VSS 0.11411f
C3189 OUT.n1589 VSS 0.11411f
C3190 OUT.t983 VSS 0.01455f
C3191 OUT.n1590 VSS 0.03282f
C3192 OUT.t828 VSS 0.01455f
C3193 OUT.n1591 VSS 0.03335f
C3194 OUT.n1592 VSS 0.11683f
C3195 OUT.n1593 VSS 0.11683f
C3196 OUT.t532 VSS 0.01455f
C3197 OUT.n1594 VSS 0.03408f
C3198 OUT.t239 VSS 0.01455f
C3199 OUT.n1595 VSS 0.03282f
C3200 OUT.n1596 VSS 0.11411f
C3201 OUT.n1597 VSS 0.11411f
C3202 OUT.t951 VSS 0.01455f
C3203 OUT.n1598 VSS 0.0328f
C3204 OUT.t996 VSS 0.01455f
C3205 OUT.n1599 VSS 0.03282f
C3206 OUT.n1600 VSS 0.11683f
C3207 OUT.n1601 VSS 0.11683f
C3208 OUT.t690 VSS 0.01455f
C3209 OUT.n1602 VSS 0.03462f
C3210 OUT.t388 VSS 0.01455f
C3211 OUT.n1603 VSS 0.03284f
C3212 OUT.n1604 VSS 0.11411f
C3213 OUT.n1605 VSS 0.11411f
C3214 OUT.t353 VSS 0.01455f
C3215 OUT.n1606 VSS 0.03355f
C3216 OUT.t48 VSS 0.01455f
C3217 OUT.n1607 VSS 0.0318f
C3218 OUT.n1608 VSS 0.11411f
C3219 OUT.n1609 VSS 0.11411f
C3220 OUT.t85 VSS 0.01455f
C3221 OUT.n1610 VSS 0.03282f
C3222 OUT.t802 VSS 0.01455f
C3223 OUT.n1611 VSS 0.03335f
C3224 OUT.n1612 VSS 0.11683f
C3225 OUT.n1613 VSS 0.11683f
C3226 OUT.t252 VSS 0.01455f
C3227 OUT.n1614 VSS 0.03408f
C3228 OUT.t219 VSS 0.01455f
C3229 OUT.n1615 VSS 0.03282f
C3230 OUT.n1616 VSS 0.11411f
C3231 OUT.n1617 VSS 0.11411f
C3232 OUT.t931 VSS 0.01455f
C3233 OUT.n1618 VSS 0.0328f
C3234 OUT.t965 VSS 0.01455f
C3235 OUT.n1619 VSS 0.03282f
C3236 OUT.n1620 VSS 0.11411f
C3237 OUT.n1621 VSS 0.11411f
C3238 OUT.t668 VSS 0.01455f
C3239 OUT.n1622 VSS 0.03285f
C3240 OUT.t364 VSS 0.01455f
C3241 OUT.n1623 VSS 0.03388f
C3242 OUT.n1624 VSS 0.11683f
C3243 OUT.n1625 VSS 0.11683f
C3244 OUT.t329 VSS 0.01455f
C3245 OUT.n1626 VSS 0.03355f
C3246 OUT.t21 VSS 0.01455f
C3247 OUT.n1627 VSS 0.0318f
C3248 OUT.n1628 VSS 0.11411f
C3249 OUT.n1629 VSS 0.11411f
C3250 OUT.t827 VSS 0.01455f
C3251 OUT.n1630 VSS 0.03282f
C3252 OUT.t531 VSS 0.01455f
C3253 OUT.n1631 VSS 0.03335f
C3254 OUT.n1632 VSS 0.11683f
C3255 OUT.n1633 VSS 0.11683f
C3256 OUT.t230 VSS 0.01455f
C3257 OUT.n1634 VSS 0.03408f
C3258 OUT.t196 VSS 0.01455f
C3259 OUT.n1635 VSS 0.03282f
C3260 OUT.n1636 VSS 0.11411f
C3261 OUT.n1637 VSS 0.11411f
C3262 OUT.t234 VSS 0.01455f
C3263 OUT.n1638 VSS 0.0328f
C3264 OUT.t943 VSS 0.01455f
C3265 OUT.n1639 VSS 0.03282f
C3266 OUT.n1640 VSS 0.11411f
C3267 OUT.n1641 VSS 0.11411f
C3268 OUT.t648 VSS 0.01455f
C3269 OUT.n1642 VSS 0.03285f
C3270 OUT.t339 VSS 0.01455f
C3271 OUT.n1643 VSS 0.03388f
C3272 OUT.n1644 VSS 0.11411f
C3273 OUT.n1645 VSS 0.11411f
C3274 OUT.t47 VSS 0.01455f
C3275 OUT.n1646 VSS 0.03289f
C3276 OUT.t84 VSS 0.01455f
C3277 OUT.n1647 VSS 0.03495f
C3278 OUT.n1648 VSS 0.11683f
C3279 OUT.n1649 VSS 0.11683f
C3280 OUT.t801 VSS 0.01455f
C3281 OUT.n1650 VSS 0.03282f
C3282 OUT.t507 VSS 0.01455f
C3283 OUT.n1651 VSS 0.03335f
C3284 OUT.n1652 VSS 0.11411f
C3285 OUT.n1653 VSS 0.11411f
C3286 OUT.t207 VSS 0.01455f
C3287 OUT.n1654 VSS 0.03287f
C3288 OUT.t168 VSS 0.01455f
C3289 OUT.n1655 VSS 0.03442f
C3290 OUT.n1656 VSS 0.11683f
C3291 OUT.n1657 VSS 0.11683f
C3292 OUT.t212 VSS 0.01455f
C3293 OUT.n1658 VSS 0.0328f
C3294 OUT.t924 VSS 0.01455f
C3295 OUT.n1659 VSS 0.03282f
C3296 OUT.n1660 VSS 0.11411f
C3297 OUT.n1661 VSS 0.11411f
C3298 OUT.t628 VSS 0.01455f
C3299 OUT.n1662 VSS 0.03285f
C3300 OUT.t62 VSS 0.01455f
C3301 OUT.n1663 VSS 0.03388f
C3302 OUT.n1664 VSS 0.11411f
C3303 OUT.n1665 VSS 0.11411f
C3304 OUT.t369 VSS 0.01455f
C3305 OUT.n1666 VSS 0.03289f
C3306 OUT.t64 VSS 0.01455f
C3307 OUT.n1667 VSS 0.03495f
C3308 OUT.n1668 VSS 0.11683f
C3309 OUT.n1669 VSS 0.11683f
C3310 OUT.t777 VSS 0.01455f
C3311 OUT.n1670 VSS 0.03282f
C3312 OUT.t484 VSS 0.01455f
C3313 OUT.n1671 VSS 0.03335f
C3314 OUT.n1672 VSS 0.11683f
C3315 OUT.n1673 VSS 0.11683f
C3316 OUT.t187 VSS 0.01455f
C3317 OUT.n1674 VSS 0.03408f
C3318 OUT.t110 VSS 0.01455f
C3319 OUT.n1675 VSS 0.03282f
C3320 OUT.n1676 VSS 0.11411f
C3321 OUT.n1677 VSS 0.11411f
C3322 OUT.t824 VSS 0.01455f
C3323 OUT.n1678 VSS 0.0328f
C3324 OUT.t275 VSS 0.01455f
C3325 OUT.n1679 VSS 0.03282f
C3326 OUT.n1680 VSS 0.11411f
C3327 OUT.n1681 VSS 0.11411f
C3328 OUT.t989 VSS 0.01455f
C3329 OUT.n1682 VSS 0.03285f
C3330 OUT.t2 VSS 0.01455f
C3331 OUT.n1683 VSS 0.03388f
C3332 OUT.n1684 VSS 0.11683f
C3333 OUT.n1685 VSS 0.11683f
C3334 OUT.t375 VSS 0.01455f
C3335 OUT.n1686 VSS 0.03355f
C3336 OUT.t675 VSS 0.01455f
C3337 OUT.n1687 VSS 0.0318f
C3338 OUT.n1688 VSS 0.12616f
C3339 OUT.n1689 VSS 0.19328f
C3340 OUT.n1690 VSS 0.17444f
C3341 OUT.n1691 VSS 0.22822f
C3342 OUT.n1692 VSS 0.55099f
C3343 OUT.n1693 VSS 0.55099f
C3344 OUT.n1694 VSS 0.14563f
C3345 OUT.t546 VSS 0.01473f
C3346 OUT.t198 VSS 0.01481f
C3347 OUT.n1695 VSS 0.33145f
C3348 OUT.t155 VSS 0.01455f
C3349 OUT.n1696 VSS 0.03189f
C3350 OUT.t865 VSS 0.01455f
C3351 OUT.n1697 VSS 0.03242f
C3352 OUT.n1698 VSS 0.11411f
C3353 OUT.n1699 VSS 0.11411f
C3354 OUT.t571 VSS 0.01455f
C3355 OUT.n1700 VSS 0.03264f
C3356 OUT.t616 VSS 0.01455f
C3357 OUT.n1701 VSS 0.0321f
C3358 OUT.n1702 VSS 0.11683f
C3359 OUT.n1703 VSS 0.11683f
C3360 OUT.t305 VSS 0.01455f
C3361 OUT.n1704 VSS 0.03157f
C3362 OUT.t271 VSS 0.01455f
C3363 OUT.n1705 VSS 0.03264f
C3364 OUT.n1706 VSS 0.11411f
C3365 OUT.n1707 VSS 0.11411f
C3366 OUT.t985 VSS 0.01455f
C3367 OUT.n1708 VSS 0.03264f
C3368 OUT.t433 VSS 0.01455f
C3369 OUT.n1709 VSS 0.03264f
C3370 OUT.n1710 VSS 0.11683f
C3371 OUT.n1711 VSS 0.11683f
C3372 OUT.t476 VSS 0.01455f
C3373 OUT.n1712 VSS 0.03104f
C3374 OUT.t172 VSS 0.01455f
C3375 OUT.n1713 VSS 0.03264f
C3376 OUT.n1714 VSS 0.11411f
C3377 OUT.n1715 VSS 0.11411f
C3378 OUT.t129 VSS 0.01455f
C3379 OUT.n1716 VSS 0.0321f
C3380 OUT.t841 VSS 0.01455f
C3381 OUT.n1717 VSS 0.03264f
C3382 OUT.n1718 VSS 0.11411f
C3383 OUT.n1719 VSS 0.11411f
C3384 OUT.t548 VSS 0.01455f
C3385 OUT.n1720 VSS 0.03242f
C3386 OUT.t394 VSS 0.01455f
C3387 OUT.n1721 VSS 0.03189f
C3388 OUT.n1722 VSS 0.11683f
C3389 OUT.n1723 VSS 0.11683f
C3390 OUT.t87 VSS 0.01455f
C3391 OUT.n1724 VSS 0.03136f
C3392 OUT.t811 VSS 0.01455f
C3393 OUT.n1725 VSS 0.03242f
C3394 OUT.n1726 VSS 0.11411f
C3395 OUT.n1727 VSS 0.11411f
C3396 OUT.t520 VSS 0.01455f
C3397 OUT.n1728 VSS 0.03242f
C3398 OUT.t561 VSS 0.01455f
C3399 OUT.n1729 VSS 0.03242f
C3400 OUT.n1730 VSS 0.11683f
C3401 OUT.n1731 VSS 0.11683f
C3402 OUT.t256 VSS 0.01455f
C3403 OUT.n1732 VSS 0.03082f
C3404 OUT.t966 VSS 0.01455f
C3405 OUT.n1733 VSS 0.03242f
C3406 OUT.n1734 VSS 0.11411f
C3407 OUT.n1735 VSS 0.11411f
C3408 OUT.t936 VSS 0.01455f
C3409 OUT.n1736 VSS 0.03189f
C3410 OUT.t640 VSS 0.01455f
C3411 OUT.n1737 VSS 0.03242f
C3412 OUT.n1738 VSS 0.11411f
C3413 OUT.n1739 VSS 0.11411f
C3414 OUT.t672 VSS 0.01455f
C3415 OUT.n1740 VSS 0.03242f
C3416 OUT.t371 VSS 0.01455f
C3417 OUT.n1741 VSS 0.03189f
C3418 OUT.n1742 VSS 0.11683f
C3419 OUT.n1743 VSS 0.11683f
C3420 OUT.t829 VSS 0.01455f
C3421 OUT.n1744 VSS 0.03136f
C3422 OUT.t791 VSS 0.01455f
C3423 OUT.n1745 VSS 0.03242f
C3424 OUT.n1746 VSS 0.11411f
C3425 OUT.n1747 VSS 0.11411f
C3426 OUT.t496 VSS 0.01455f
C3427 OUT.n1748 VSS 0.03242f
C3428 OUT.t538 VSS 0.01455f
C3429 OUT.n1749 VSS 0.03242f
C3430 OUT.n1750 VSS 0.11411f
C3431 OUT.n1751 VSS 0.11411f
C3432 OUT.t235 VSS 0.01455f
C3433 OUT.n1752 VSS 0.03242f
C3434 OUT.t944 VSS 0.01455f
C3435 OUT.n1753 VSS 0.03136f
C3436 OUT.n1754 VSS 0.11683f
C3437 OUT.n1755 VSS 0.11683f
C3438 OUT.t907 VSS 0.01455f
C3439 OUT.n1756 VSS 0.03189f
C3440 OUT.t613 VSS 0.01455f
C3441 OUT.n1757 VSS 0.03242f
C3442 OUT.n1758 VSS 0.11411f
C3443 OUT.n1759 VSS 0.11411f
C3444 OUT.t393 VSS 0.01455f
C3445 OUT.n1760 VSS 0.03242f
C3446 OUT.t86 VSS 0.01455f
C3447 OUT.n1761 VSS 0.03189f
C3448 OUT.n1762 VSS 0.11683f
C3449 OUT.n1763 VSS 0.11683f
C3450 OUT.t803 VSS 0.01455f
C3451 OUT.n1764 VSS 0.03136f
C3452 OUT.t762 VSS 0.01455f
C3453 OUT.n1765 VSS 0.03242f
C3454 OUT.n1766 VSS 0.11411f
C3455 OUT.n1767 VSS 0.11411f
C3456 OUT.t806 VSS 0.01455f
C3457 OUT.n1768 VSS 0.03242f
C3458 OUT.t513 VSS 0.01455f
C3459 OUT.n1769 VSS 0.03242f
C3460 OUT.n1770 VSS 0.11411f
C3461 OUT.n1771 VSS 0.11411f
C3462 OUT.t213 VSS 0.01455f
C3463 OUT.n1772 VSS 0.03242f
C3464 OUT.t925 VSS 0.01455f
C3465 OUT.n1773 VSS 0.03136f
C3466 OUT.n1774 VSS 0.11411f
C3467 OUT.n1775 VSS 0.11411f
C3468 OUT.t636 VSS 0.01455f
C3469 OUT.n1776 VSS 0.03242f
C3470 OUT.t671 VSS 0.01455f
C3471 OUT.n1777 VSS 0.03029f
C3472 OUT.n1778 VSS 0.11683f
C3473 OUT.n1779 VSS 0.11683f
C3474 OUT.t370 VSS 0.01455f
C3475 OUT.n1780 VSS 0.03242f
C3476 OUT.t65 VSS 0.01455f
C3477 OUT.n1781 VSS 0.03189f
C3478 OUT.n1782 VSS 0.11411f
C3479 OUT.n1783 VSS 0.11411f
C3480 OUT.t778 VSS 0.01455f
C3481 OUT.n1784 VSS 0.03242f
C3482 OUT.t735 VSS 0.01455f
C3483 OUT.n1785 VSS 0.03082f
C3484 OUT.n1786 VSS 0.11683f
C3485 OUT.n1787 VSS 0.11683f
C3486 OUT.t782 VSS 0.01455f
C3487 OUT.n1788 VSS 0.03242f
C3488 OUT.t490 VSS 0.01455f
C3489 OUT.n1789 VSS 0.03242f
C3490 OUT.n1790 VSS 0.11411f
C3491 OUT.n1791 VSS 0.11411f
C3492 OUT.t193 VSS 0.01455f
C3493 OUT.n1792 VSS 0.03242f
C3494 OUT.t647 VSS 0.01455f
C3495 OUT.n1793 VSS 0.03136f
C3496 OUT.n1794 VSS 0.11411f
C3497 OUT.n1795 VSS 0.11411f
C3498 OUT.t948 VSS 0.01455f
C3499 OUT.n1796 VSS 0.03242f
C3500 OUT.t655 VSS 0.01455f
C3501 OUT.n1797 VSS 0.03029f
C3502 OUT.n1798 VSS 0.11683f
C3503 OUT.n1799 VSS 0.11683f
C3504 OUT.t344 VSS 0.01455f
C3505 OUT.n1800 VSS 0.03242f
C3506 OUT.t39 VSS 0.01455f
C3507 OUT.n1801 VSS 0.03189f
C3508 OUT.n1802 VSS 0.11683f
C3509 OUT.n1803 VSS 0.11683f
C3510 OUT.t753 VSS 0.01455f
C3511 OUT.n1804 VSS 0.03136f
C3512 OUT.t693 VSS 0.01455f
C3513 OUT.n1805 VSS 0.03242f
C3514 OUT.n1806 VSS 0.11411f
C3515 OUT.n1807 VSS 0.11411f
C3516 OUT.t390 VSS 0.01455f
C3517 OUT.n1808 VSS 0.03242f
C3518 OUT.t848 VSS 0.01455f
C3519 OUT.n1809 VSS 0.03242f
C3520 OUT.n1810 VSS 0.11411f
C3521 OUT.n1811 VSS 0.11411f
C3522 OUT.t558 VSS 0.01455f
C3523 OUT.n1812 VSS 0.03242f
C3524 OUT.t591 VSS 0.01455f
C3525 OUT.n1813 VSS 0.03136f
C3526 OUT.n1814 VSS 0.11683f
C3527 OUT.n1815 VSS 0.11683f
C3528 OUT.t955 VSS 0.01455f
C3529 OUT.n1816 VSS 0.03189f
C3530 OUT.t244 VSS 0.01455f
C3531 OUT.n1817 VSS 0.03242f
C3532 OUT.n1818 VSS 0.12616f
C3533 OUT.n1819 VSS 0.1935f
C3534 OUT.n1820 VSS 0.15923f
C3535 OUT.n1821 VSS 0.13693f
C3536 OUT.n1822 VSS 0.55099f
C3537 OUT.n1823 VSS 0.27604f
C3538 OUT.t40 VSS 0.01473f
C3539 OUT.t709 VSS 0.01481f
C3540 OUT.n1824 VSS 0.33065f
C3541 OUT.t674 VSS 0.01455f
C3542 OUT.n1825 VSS 0.03331f
C3543 OUT.t372 VSS 0.01455f
C3544 OUT.n1826 VSS 0.03205f
C3545 OUT.n1827 VSS 0.11411f
C3546 OUT.n1828 VSS 0.11411f
C3547 OUT.t67 VSS 0.01455f
C3548 OUT.n1829 VSS 0.03277f
C3549 OUT.t111 VSS 0.01455f
C3550 OUT.n1830 VSS 0.0333f
C3551 OUT.n1831 VSS 0.11683f
C3552 OUT.n1832 VSS 0.11683f
C3553 OUT.t825 VSS 0.01455f
C3554 OUT.n1833 VSS 0.03406f
C3555 OUT.t792 VSS 0.01455f
C3556 OUT.n1834 VSS 0.03277f
C3557 OUT.n1835 VSS 0.11411f
C3558 OUT.n1836 VSS 0.11411f
C3559 OUT.t497 VSS 0.01455f
C3560 OUT.n1837 VSS 0.03277f
C3561 OUT.t946 VSS 0.01455f
C3562 OUT.n1838 VSS 0.03277f
C3563 OUT.n1839 VSS 0.11683f
C3564 OUT.n1840 VSS 0.11683f
C3565 OUT.t992 VSS 0.01455f
C3566 OUT.n1841 VSS 0.03459f
C3567 OUT.t688 VSS 0.01455f
C3568 OUT.n1842 VSS 0.03278f
C3569 OUT.n1843 VSS 0.11411f
C3570 OUT.n1844 VSS 0.11411f
C3571 OUT.t659 VSS 0.01455f
C3572 OUT.n1845 VSS 0.03352f
C3573 OUT.t347 VSS 0.01455f
C3574 OUT.n1846 VSS 0.03226f
C3575 OUT.n1847 VSS 0.11411f
C3576 OUT.n1848 VSS 0.11411f
C3577 OUT.t42 VSS 0.01455f
C3578 OUT.n1849 VSS 0.03256f
C3579 OUT.t914 VSS 0.01455f
C3580 OUT.n1850 VSS 0.03309f
C3581 OUT.n1851 VSS 0.11683f
C3582 OUT.n1852 VSS 0.11683f
C3583 OUT.t620 VSS 0.01455f
C3584 OUT.n1853 VSS 0.03384f
C3585 OUT.t316 VSS 0.01455f
C3586 OUT.n1854 VSS 0.03256f
C3587 OUT.n1855 VSS 0.11411f
C3588 OUT.n1856 VSS 0.11411f
C3589 OUT.t10 VSS 0.01455f
C3590 OUT.n1857 VSS 0.03255f
C3591 OUT.t60 VSS 0.01455f
C3592 OUT.n1858 VSS 0.03256f
C3593 OUT.n1859 VSS 0.11683f
C3594 OUT.n1860 VSS 0.11683f
C3595 OUT.t771 VSS 0.01455f
C3596 OUT.n1861 VSS 0.03438f
C3597 OUT.t479 VSS 0.01455f
C3598 OUT.n1862 VSS 0.03257f
C3599 OUT.n1863 VSS 0.11411f
C3600 OUT.n1864 VSS 0.11411f
C3601 OUT.t441 VSS 0.01455f
C3602 OUT.n1865 VSS 0.03331f
C3603 OUT.t134 VSS 0.01455f
C3604 OUT.n1866 VSS 0.03205f
C3605 OUT.n1867 VSS 0.11411f
C3606 OUT.n1868 VSS 0.11411f
C3607 OUT.t180 VSS 0.01455f
C3608 OUT.n1869 VSS 0.03256f
C3609 OUT.t886 VSS 0.01455f
C3610 OUT.n1870 VSS 0.03309f
C3611 OUT.n1871 VSS 0.11683f
C3612 OUT.n1872 VSS 0.11683f
C3613 OUT.t334 VSS 0.01455f
C3614 OUT.n1873 VSS 0.03384f
C3615 OUT.t294 VSS 0.01455f
C3616 OUT.n1874 VSS 0.03256f
C3617 OUT.n1875 VSS 0.11411f
C3618 OUT.n1876 VSS 0.11411f
C3619 OUT.t1015 VSS 0.01455f
C3620 OUT.n1877 VSS 0.03255f
C3621 OUT.t32 VSS 0.01455f
C3622 OUT.n1878 VSS 0.03256f
C3623 OUT.n1879 VSS 0.11411f
C3624 OUT.n1880 VSS 0.11411f
C3625 OUT.t742 VSS 0.01455f
C3626 OUT.n1881 VSS 0.03257f
C3627 OUT.t450 VSS 0.01455f
C3628 OUT.n1882 VSS 0.03362f
C3629 OUT.n1883 VSS 0.11683f
C3630 OUT.n1884 VSS 0.11683f
C3631 OUT.t415 VSS 0.01455f
C3632 OUT.n1885 VSS 0.03331f
C3633 OUT.t107 VSS 0.01455f
C3634 OUT.n1886 VSS 0.03205f
C3635 OUT.n1887 VSS 0.11411f
C3636 OUT.n1888 VSS 0.11411f
C3637 OUT.t913 VSS 0.01455f
C3638 OUT.n1889 VSS 0.03256f
C3639 OUT.t619 VSS 0.01455f
C3640 OUT.n1890 VSS 0.03309f
C3641 OUT.n1891 VSS 0.11683f
C3642 OUT.n1892 VSS 0.11683f
C3643 OUT.t307 VSS 0.01455f
C3644 OUT.n1893 VSS 0.03384f
C3645 OUT.t276 VSS 0.01455f
C3646 OUT.n1894 VSS 0.03256f
C3647 OUT.n1895 VSS 0.11411f
C3648 OUT.n1896 VSS 0.11411f
C3649 OUT.t310 VSS 0.01455f
C3650 OUT.n1897 VSS 0.03255f
C3651 OUT.t3 VSS 0.01455f
C3652 OUT.n1898 VSS 0.03256f
C3653 OUT.n1899 VSS 0.11411f
C3654 OUT.n1900 VSS 0.11411f
C3655 OUT.t717 VSS 0.01455f
C3656 OUT.n1901 VSS 0.03257f
C3657 OUT.t430 VSS 0.01455f
C3658 OUT.n1902 VSS 0.03362f
C3659 OUT.n1903 VSS 0.11411f
C3660 OUT.n1904 VSS 0.11411f
C3661 OUT.t132 VSS 0.01455f
C3662 OUT.n1905 VSS 0.0326f
C3663 OUT.t179 VSS 0.01455f
C3664 OUT.n1906 VSS 0.03469f
C3665 OUT.n1907 VSS 0.11683f
C3666 OUT.n1908 VSS 0.11683f
C3667 OUT.t885 VSS 0.01455f
C3668 OUT.n1909 VSS 0.03256f
C3669 OUT.t592 VSS 0.01455f
C3670 OUT.n1910 VSS 0.03309f
C3671 OUT.n1911 VSS 0.11411f
C3672 OUT.n1912 VSS 0.11411f
C3673 OUT.t283 VSS 0.01455f
C3674 OUT.n1913 VSS 0.03258f
C3675 OUT.t250 VSS 0.01455f
C3676 OUT.n1914 VSS 0.03415f
C3677 OUT.n1915 VSS 0.11683f
C3678 OUT.n1916 VSS 0.11683f
C3679 OUT.t287 VSS 0.01455f
C3680 OUT.n1917 VSS 0.03255f
C3681 OUT.t1005 VSS 0.01455f
C3682 OUT.n1918 VSS 0.03256f
C3683 OUT.n1919 VSS 0.11411f
C3684 OUT.n1920 VSS 0.11411f
C3685 OUT.t699 VSS 0.01455f
C3686 OUT.n1921 VSS 0.03257f
C3687 OUT.t146 VSS 0.01455f
C3688 OUT.n1922 VSS 0.03362f
C3689 OUT.n1923 VSS 0.11411f
C3690 OUT.n1924 VSS 0.11411f
C3691 OUT.t456 VSS 0.01455f
C3692 OUT.n1925 VSS 0.0326f
C3693 OUT.t152 VSS 0.01455f
C3694 OUT.n1926 VSS 0.03469f
C3695 OUT.n1927 VSS 0.11683f
C3696 OUT.n1928 VSS 0.11683f
C3697 OUT.t862 VSS 0.01455f
C3698 OUT.n1929 VSS 0.03256f
C3699 OUT.t569 VSS 0.01455f
C3700 OUT.n1930 VSS 0.03309f
C3701 OUT.n1931 VSS 0.11683f
C3702 OUT.n1932 VSS 0.11683f
C3703 OUT.t264 VSS 0.01455f
C3704 OUT.n1933 VSS 0.03384f
C3705 OUT.t203 VSS 0.01455f
C3706 OUT.n1934 VSS 0.03256f
C3707 OUT.n1935 VSS 0.11411f
C3708 OUT.n1936 VSS 0.11411f
C3709 OUT.t911 VSS 0.01455f
C3710 OUT.n1937 VSS 0.03255f
C3711 OUT.t356 VSS 0.01455f
C3712 OUT.n1938 VSS 0.03256f
C3713 OUT.n1939 VSS 0.11411f
C3714 OUT.n1940 VSS 0.11411f
C3715 OUT.t52 VSS 0.01455f
C3716 OUT.n1941 VSS 0.03257f
C3717 OUT.t88 VSS 0.01455f
C3718 OUT.n1942 VSS 0.03362f
C3719 OUT.n1943 VSS 0.11683f
C3720 OUT.n1944 VSS 0.11683f
C3721 OUT.t463 VSS 0.01455f
C3722 OUT.n1945 VSS 0.03331f
C3723 OUT.t754 VSS 0.01455f
C3724 OUT.n1946 VSS 0.03205f
C3725 OUT.n1947 VSS 0.12616f
C3726 OUT.n1948 VSS 0.19327f
C3727 OUT.n1949 VSS 0.13041f
C3728 OUT.n1950 VSS 0.6105f
C3729 OUT.n1951 VSS 0.95024f
C3730 OUT.t918 VSS 0.01473f
C3731 OUT.t578 VSS 0.01481f
C3732 OUT.n1952 VSS 0.3309f
C3733 OUT.t536 VSS 0.01455f
C3734 OUT.n1953 VSS 0.03307f
C3735 OUT.t232 VSS 0.01455f
C3736 OUT.n1954 VSS 0.0323f
C3737 OUT.n1955 VSS 0.11411f
C3738 OUT.n1956 VSS 0.11411f
C3739 OUT.t942 VSS 0.01455f
C3740 OUT.n1957 VSS 0.03251f
C3741 OUT.t991 VSS 0.01455f
C3742 OUT.n1958 VSS 0.03329f
C3743 OUT.n1959 VSS 0.11683f
C3744 OUT.n1960 VSS 0.11683f
C3745 OUT.t687 VSS 0.01455f
C3746 OUT.n1961 VSS 0.03381f
C3747 OUT.t656 VSS 0.01455f
C3748 OUT.n1962 VSS 0.03251f
C3749 OUT.n1963 VSS 0.11411f
C3750 OUT.n1964 VSS 0.11411f
C3751 OUT.t345 VSS 0.01455f
C3752 OUT.n1965 VSS 0.03251f
C3753 OUT.t798 VSS 0.01455f
C3754 OUT.n1966 VSS 0.03251f
C3755 OUT.n1967 VSS 0.11683f
C3756 OUT.n1968 VSS 0.11683f
C3757 OUT.t845 VSS 0.01455f
C3758 OUT.n1969 VSS 0.03434f
C3759 OUT.t553 VSS 0.01455f
C3760 OUT.n1970 VSS 0.03251f
C3761 OUT.n1971 VSS 0.11411f
C3762 OUT.n1972 VSS 0.11411f
C3763 OUT.t514 VSS 0.01455f
C3764 OUT.n1973 VSS 0.03329f
C3765 OUT.t214 VSS 0.01455f
C3766 OUT.n1974 VSS 0.03251f
C3767 OUT.n1975 VSS 0.11411f
C3768 OUT.n1976 VSS 0.11411f
C3769 OUT.t926 VSS 0.01455f
C3770 OUT.n1977 VSS 0.03242f
C3771 OUT.t767 VSS 0.01455f
C3772 OUT.n1978 VSS 0.0332f
C3773 OUT.n1979 VSS 0.11683f
C3774 OUT.n1980 VSS 0.11683f
C3775 OUT.t475 VSS 0.01455f
C3776 OUT.n1981 VSS 0.03371f
C3777 OUT.t184 VSS 0.01455f
C3778 OUT.n1982 VSS 0.03242f
C3779 OUT.n1983 VSS 0.11411f
C3780 OUT.n1984 VSS 0.11411f
C3781 OUT.t890 VSS 0.01455f
C3782 OUT.n1985 VSS 0.03217f
C3783 OUT.t939 VSS 0.01455f
C3784 OUT.n1986 VSS 0.03242f
C3785 OUT.n1987 VSS 0.11683f
C3786 OUT.n1988 VSS 0.11683f
C3787 OUT.t641 VSS 0.01455f
C3788 OUT.n1989 VSS 0.03425f
C3789 OUT.t331 VSS 0.01455f
C3790 OUT.n1990 VSS 0.03243f
C3791 OUT.n1991 VSS 0.11411f
C3792 OUT.n1992 VSS 0.11411f
C3793 OUT.t291 VSS 0.01455f
C3794 OUT.n1993 VSS 0.03319f
C3795 OUT.t1011 VSS 0.01455f
C3796 OUT.n1994 VSS 0.03217f
C3797 OUT.n1995 VSS 0.11411f
C3798 OUT.n1996 VSS 0.11411f
C3799 OUT.t28 VSS 0.01455f
C3800 OUT.n1997 VSS 0.03242f
C3801 OUT.t739 VSS 0.01455f
C3802 OUT.n1998 VSS 0.0332f
C3803 OUT.n1999 VSS 0.11683f
C3804 OUT.n2000 VSS 0.11683f
C3805 OUT.t199 VSS 0.01455f
C3806 OUT.n2001 VSS 0.03371f
C3807 OUT.t156 VSS 0.01455f
C3808 OUT.n2002 VSS 0.03242f
C3809 OUT.n2003 VSS 0.11411f
C3810 OUT.n2004 VSS 0.11411f
C3811 OUT.t866 VSS 0.01455f
C3812 OUT.n2005 VSS 0.03217f
C3813 OUT.t909 VSS 0.01455f
C3814 OUT.n2006 VSS 0.03242f
C3815 OUT.n2007 VSS 0.11411f
C3816 OUT.n2008 VSS 0.11411f
C3817 OUT.t614 VSS 0.01455f
C3818 OUT.n2009 VSS 0.03243f
C3819 OUT.t304 VSS 0.01455f
C3820 OUT.n2010 VSS 0.03372f
C3821 OUT.n2011 VSS 0.11683f
C3822 OUT.n2012 VSS 0.11683f
C3823 OUT.t272 VSS 0.01455f
C3824 OUT.n2013 VSS 0.03319f
C3825 OUT.t986 VSS 0.01455f
C3826 OUT.n2014 VSS 0.03217f
C3827 OUT.n2015 VSS 0.11411f
C3828 OUT.n2016 VSS 0.11411f
C3829 OUT.t766 VSS 0.01455f
C3830 OUT.n2017 VSS 0.03242f
C3831 OUT.t474 VSS 0.01455f
C3832 OUT.n2018 VSS 0.0332f
C3833 OUT.n2019 VSS 0.11683f
C3834 OUT.n2020 VSS 0.11683f
C3835 OUT.t171 VSS 0.01455f
C3836 OUT.n2021 VSS 0.03371f
C3837 OUT.t130 VSS 0.01455f
C3838 OUT.n2022 VSS 0.03242f
C3839 OUT.n2023 VSS 0.11411f
C3840 OUT.n2024 VSS 0.11411f
C3841 OUT.t173 VSS 0.01455f
C3842 OUT.n2025 VSS 0.03217f
C3843 OUT.t884 VSS 0.01455f
C3844 OUT.n2026 VSS 0.03242f
C3845 OUT.n2027 VSS 0.11411f
C3846 OUT.n2028 VSS 0.11411f
C3847 OUT.t586 VSS 0.01455f
C3848 OUT.n2029 VSS 0.03243f
C3849 OUT.t280 VSS 0.01455f
C3850 OUT.n2030 VSS 0.03372f
C3851 OUT.n2031 VSS 0.11411f
C3852 OUT.n2032 VSS 0.11411f
C3853 OUT.t1006 VSS 0.01455f
C3854 OUT.n2033 VSS 0.03244f
C3855 OUT.t27 VSS 0.01455f
C3856 OUT.n2034 VSS 0.03478f
C3857 OUT.n2035 VSS 0.11683f
C3858 OUT.n2036 VSS 0.11683f
C3859 OUT.t738 VSS 0.01455f
C3860 OUT.n2037 VSS 0.03242f
C3861 OUT.t447 VSS 0.01455f
C3862 OUT.n2038 VSS 0.0332f
C3863 OUT.n2039 VSS 0.11411f
C3864 OUT.n2040 VSS 0.11411f
C3865 OUT.t143 VSS 0.01455f
C3866 OUT.n2041 VSS 0.03244f
C3867 OUT.t105 VSS 0.01455f
C3868 OUT.n2042 VSS 0.03426f
C3869 OUT.n2043 VSS 0.11683f
C3870 OUT.n2044 VSS 0.11683f
C3871 OUT.t147 VSS 0.01455f
C3872 OUT.n2045 VSS 0.03217f
C3873 OUT.t858 VSS 0.01455f
C3874 OUT.n2046 VSS 0.03242f
C3875 OUT.n2047 VSS 0.11411f
C3876 OUT.n2048 VSS 0.11411f
C3877 OUT.t565 VSS 0.01455f
C3878 OUT.n2049 VSS 0.03243f
C3879 OUT.t1023 VSS 0.01455f
C3880 OUT.n2050 VSS 0.03372f
C3881 OUT.n2051 VSS 0.11411f
C3882 OUT.n2052 VSS 0.11411f
C3883 OUT.t308 VSS 0.01455f
C3884 OUT.n2053 VSS 0.03244f
C3885 OUT.t1 VSS 0.01455f
C3886 OUT.n2054 VSS 0.03478f
C3887 OUT.n2055 VSS 0.11683f
C3888 OUT.n2056 VSS 0.11683f
C3889 OUT.t714 VSS 0.01455f
C3890 OUT.n2057 VSS 0.03242f
C3891 OUT.t426 VSS 0.01455f
C3892 OUT.n2058 VSS 0.0332f
C3893 OUT.n2059 VSS 0.11683f
C3894 OUT.n2060 VSS 0.11683f
C3895 OUT.t116 VSS 0.01455f
C3896 OUT.n2061 VSS 0.03371f
C3897 OUT.t55 VSS 0.01455f
C3898 OUT.n2062 VSS 0.03242f
C3899 OUT.n2063 VSS 0.11411f
C3900 OUT.n2064 VSS 0.11411f
C3901 OUT.t765 VSS 0.01455f
C3902 OUT.n2065 VSS 0.03217f
C3903 OUT.t216 VSS 0.01455f
C3904 OUT.n2066 VSS 0.03242f
C3905 OUT.n2067 VSS 0.11411f
C3906 OUT.n2068 VSS 0.11411f
C3907 OUT.t928 VSS 0.01455f
C3908 OUT.n2069 VSS 0.03243f
C3909 OUT.t962 VSS 0.01455f
C3910 OUT.n2070 VSS 0.03372f
C3911 OUT.n2071 VSS 0.11683f
C3912 OUT.n2072 VSS 0.11683f
C3913 OUT.t311 VSS 0.01455f
C3914 OUT.n2073 VSS 0.03319f
C3915 OUT.t625 VSS 0.01455f
C3916 OUT.n2074 VSS 0.03217f
C3917 OUT.n2075 VSS 0.12616f
C3918 OUT.n2076 VSS 0.19338f
C3919 OUT.n2077 VSS 0.61551f
C3920 OUT.n2078 VSS 0.13476f
C3921 OUT.n2079 VSS 0.28256f
C3922 OUT.n2080 VSS 0.13041f
C3923 OUT.n2081 VSS 0.13693f
C3924 OUT.n2082 VSS 0.13693f
C3925 OUT.n2083 VSS 0.22822f
C3926 OUT.n2084 VSS 0.18966f
C3927 OUT.n2085 VSS 0.05434f
C3928 OUT.n2086 VSS 0.15215f
C3929 OUT.n2087 VSS 0.13693f
C3930 OUT.n2088 VSS 0.26082f
C3931 OUT.n2089 VSS 0.26082f
C3932 OUT.n2090 VSS 0.14563f
C3933 OUT.n2091 VSS 0.0326f
C3934 OUT.n2092 VSS 0.13041f
C3935 OUT.n2093 VSS 0.24561f
C3936 OUT.n2094 VSS 0.16736f
C3937 OUT.n2095 VSS 0.16736f
C3938 OUT.n2096 VSS 0.13041f
C3939 OUT.n2097 VSS 0.10433f
C3940 OUT.n2098 VSS 0.22387f
C3941 OUT.n2099 VSS 0.1891f
C3942 OUT.n2100 VSS 0.15215f
C3943 OUT.n2101 VSS 0.15215f
C3944 OUT.n2102 VSS 0.19127f
C3945 OUT.n2103 VSS 0.17445f
C3946 OUT.n2104 VSS 0.09129f
C3947 OUT.n2105 VSS 0.1891f
C3948 OUT.n2106 VSS 0.13041f
C3949 OUT.n2107 VSS 0.20214f
C3950 OUT.n2108 VSS 0.20214f
C3951 OUT.n2109 VSS 0.20648f
C3952 OUT.n2110 VSS 0.12445f
C3953 OUT.n2111 VSS 0.05434f
C3954 OUT.n2112 VSS 0.13041f
C3955 OUT.n2113 VSS 0.1804f
C3956 OUT.n2114 VSS 0.23257f
C3957 OUT.n2115 VSS 0.23257f
C3958 OUT.n2116 VSS 0.13041f
C3959 OUT.n2117 VSS 0.06086f
C3960 OUT.n2118 VSS 0.1804f
C3961 OUT.n2119 VSS 0.2543f
C3962 OUT.n2120 VSS 0.13041f
C3963 OUT.n2121 VSS 0.13041f
C3964 OUT.n2122 VSS 0.1478f
C3965 OUT.n2123 VSS 0.17445f
C3966 OUT.n2124 VSS 0.13476f
C3967 OUT.n2125 VSS 0.2543f
C3968 OUT.n2126 VSS 0.13041f
C3969 OUT.n2127 VSS 0.13693f
C3970 OUT.n2128 VSS 0.13693f
C3971 OUT.n2129 VSS 0.22822f
C3972 OUT.n2130 VSS 0.17444f
C3973 OUT.n2131 VSS 0.04782f
C3974 OUT.n2132 VSS 0.14563f
C3975 OUT.n2133 VSS 0.13041f
C3976 OUT.n2134 VSS 0.26734f
C3977 OUT.n2135 VSS 0.26734f
C3978 OUT.n2136 VSS 0.16736f
C3979 OUT.n2137 VSS 0.05434f
C3980 OUT.n2138 VSS 0.13041f
C3981 OUT.n2139 VSS 0.24561f
C3982 OUT.n2140 VSS 0.16736f
C3983 OUT.n2141 VSS 0.16736f
C3984 OUT.n2142 VSS 0.13041f
C3985 OUT.n2143 VSS 0.10433f
C3986 OUT.n2144 VSS 0.22387f
C3987 OUT.n2145 VSS 0.1891f
C3988 OUT.n2146 VSS 0.17823f
C3989 OUT.n2147 VSS 0.13041f
C3990 OUT.n2148 VSS 0.19127f
C3991 OUT.n2149 VSS 0.20214f
C3992 OUT.n2150 VSS 0.21083f
C3993 OUT.n2151 VSS 0.15215f
C3994 OUT.n2152 VSS 0.15215f
C3995 OUT.n2153 VSS 0.20214f
C3996 OUT.n2154 VSS 0.16736f
C3997 OUT.n2155 VSS 0.21083f
C3998 OUT.n2156 VSS 0.13041f
C3999 OUT.n2157 VSS 0.05434f
C4000 OUT.n2158 VSS 0.1804f
C4001 OUT.n2159 VSS 0.21083f
C4002 OUT.n2160 VSS 0.2217f
C4003 OUT.n2161 VSS 0.10215f
C4004 OUT.n2162 VSS 0.04999f
C4005 OUT.n2163 VSS 0.07173f
C4006 OUT.n2164 VSS 0.17444f
C4007 OUT.n2165 VSS 0.2217f
C4008 OUT.n2166 VSS 0.2543f
C4009 OUT.n2167 VSS 0.13041f
C4010 OUT.n2168 VSS 0.13693f
C4011 OUT.n2169 VSS 0.13693f
C4012 OUT.n2170 VSS 0.14128f
C4013 OUT.n2171 VSS 0.17445f
C4014 OUT.n2172 VSS 0.13476f
C4015 OUT.n2173 VSS 0.14563f
C4016 OUT.n2174 VSS 0.13041f
C4017 OUT.n2175 VSS 0.24561f
C4018 OUT.n2176 VSS 0.21301f
C4019 OUT.n2177 VSS 0.17445f
C4020 OUT.n2178 VSS 0.06955f
C4021 OUT.n2179 VSS 0.13041f
C4022 OUT.n2180 VSS 0.13041f
C4023 OUT.n2181 VSS 0.62881f
C4024 OUT.n2182 VSS 1.15722f
C4025 OUT.n2183 VSS 0.49643f
C4026 OUT.n2184 VSS 2.74404f
C4027 OUT.n2186 VSS 0.44503f
C4028 OUT.n2187 VSS 0.38145f
C4029 OUT.n2188 VSS 0.5086f
C4030 OUT.n2190 VSS 0.44503f
C4031 OUT.n2192 VSS 2.62779f
C4032 OUT.n2193 VSS 16.2276f
C4033 OUT.n2194 VSS 21.169f
C4034 OUT.n2195 VSS 5.58111f
C4035 OUT.n2196 VSS 11.0642f
C4036 OUT.t0 VSS 0.07627f
C4037 OUT.n2197 VSS 3.9324f
C4038 VIN.t1085 VSS 0.00774f
C4039 VIN.t1615 VSS 0.00774f
C4040 VIN.t627 VSS 0.00774f
C4041 VIN.t350 VSS 0.00774f
C4042 VIN.t913 VSS 0.00774f
C4043 VIN.t519 VSS 0.00774f
C4044 VIN.t1653 VSS 0.00774f
C4045 VIN.t153 VSS 0.00774f
C4046 VIN.t1821 VSS 0.00774f
C4047 VIN.t53 VSS 0.00774f
C4048 VIN.t1277 VSS 0.00774f
C4049 VIN.t257 VSS 0.00774f
C4050 VIN.t1413 VSS 0.00774f
C4051 VIN.t551 VSS 0.00774f
C4052 VIN.t1571 VSS 0.00774f
C4053 VIN.t1313 VSS 0.00774f
C4054 VIN.t1899 VSS 0.00774f
C4055 VIN.n0 VSS 0.07567f
C4056 VIN.t112 VSS 0.00774f
C4057 VIN.n1 VSS 0.08863f
C4058 VIN.t1155 VSS 0.00774f
C4059 VIN.n2 VSS 0.08863f
C4060 VIN.t2017 VSS 0.00774f
C4061 VIN.n3 VSS 0.08863f
C4062 VIN.t879 VSS 0.00774f
C4063 VIN.n4 VSS 0.08863f
C4064 VIN.t1865 VSS 0.00774f
C4065 VIN.n5 VSS 0.08863f
C4066 VIN.t707 VSS 0.00774f
C4067 VIN.n6 VSS 0.08863f
C4068 VIN.t1869 VSS 0.00774f
C4069 VIN.n7 VSS 0.08863f
C4070 VIN.t201 VSS 0.00774f
C4071 VIN.n8 VSS 0.08863f
C4072 VIN.t1703 VSS 0.00774f
C4073 VIN.n9 VSS 0.08863f
C4074 VIN.t565 VSS 0.00774f
C4075 VIN.n10 VSS 0.08863f
C4076 VIN.t955 VSS 0.00774f
C4077 VIN.n11 VSS 0.08863f
C4078 VIN.t402 VSS 0.00774f
C4079 VIN.n12 VSS 0.08863f
C4080 VIN.t675 VSS 0.00774f
C4081 VIN.n13 VSS 0.08863f
C4082 VIN.t1663 VSS 0.00774f
C4083 VIN.n14 VSS 0.08863f
C4084 VIN.t1133 VSS 0.00774f
C4085 VIN.n15 VSS 0.0729f
C4086 VIN.n16 VSS 0.13958f
C4087 VIN.t1084 VSS 0.00879f
C4088 VIN.n17 VSS 0.22953f
C4089 VIN.n18 VSS 0.21493f
C4090 VIN.n19 VSS 0.29065f
C4091 VIN.t961 VSS 0.00774f
C4092 VIN.t1489 VSS 0.00774f
C4093 VIN.t521 VSS 0.00774f
C4094 VIN.t207 VSS 0.00774f
C4095 VIN.t781 VSS 0.00774f
C4096 VIN.t400 VSS 0.00774f
C4097 VIN.t1521 VSS 0.00774f
C4098 VIN.t2103 VSS 0.00774f
C4099 VIN.t1697 VSS 0.00774f
C4100 VIN.t809 VSS 0.00774f
C4101 VIN.t1967 VSS 0.00774f
C4102 VIN.t981 VSS 0.00774f
C4103 VIN.t5 VSS 0.00774f
C4104 VIN.t1245 VSS 0.00774f
C4105 VIN.t226 VSS 0.00774f
C4106 VIN.t1987 VSS 0.00774f
C4107 VIN.t685 VSS 0.00774f
C4108 VIN.n20 VSS 0.08228f
C4109 VIN.t989 VSS 0.00774f
C4110 VIN.n21 VSS 0.08806f
C4111 VIN.t1973 VSS 0.00774f
C4112 VIN.n22 VSS 0.08806f
C4113 VIN.t813 VSS 0.00774f
C4114 VIN.n23 VSS 0.08806f
C4115 VIN.t1695 VSS 0.00774f
C4116 VIN.n24 VSS 0.08806f
C4117 VIN.t661 VSS 0.00774f
C4118 VIN.n25 VSS 0.08806f
C4119 VIN.t1525 VSS 0.00774f
C4120 VIN.n26 VSS 0.08806f
C4121 VIN.t1769 VSS 0.00774f
C4122 VIN.n27 VSS 0.08806f
C4123 VIN.t83 VSS 0.00774f
C4124 VIN.n28 VSS 0.08806f
C4125 VIN.t1603 VSS 0.00774f
C4126 VIN.n29 VSS 0.08806f
C4127 VIN.t475 VSS 0.00774f
C4128 VIN.n30 VSS 0.08806f
C4129 VIN.t859 VSS 0.00774f
C4130 VIN.n31 VSS 0.08806f
C4131 VIN.t293 VSS 0.00774f
C4132 VIN.n32 VSS 0.08806f
C4133 VIN.t589 VSS 0.00774f
C4134 VIN.n33 VSS 0.08806f
C4135 VIN.t1567 VSS 0.00774f
C4136 VIN.n34 VSS 0.08806f
C4137 VIN.t1039 VSS 0.00774f
C4138 VIN.n35 VSS 0.07233f
C4139 VIN.n36 VSS 0.3224f
C4140 VIN.n37 VSS 0.18408f
C4141 VIN.t1785 VSS 0.00774f
C4142 VIN.t1737 VSS 0.00774f
C4143 VIN.n38 VSS 0.07176f
C4144 VIN.n39 VSS 0.3531f
C4145 VIN.t1210 VSS 0.00879f
C4146 VIN.n40 VSS 0.18108f
C4147 VIN.n41 VSS 0.21493f
C4148 VIN.t1211 VSS 0.00774f
C4149 VIN.t1743 VSS 0.00774f
C4150 VIN.t761 VSS 0.00774f
C4151 VIN.t485 VSS 0.00774f
C4152 VIN.t1035 VSS 0.00774f
C4153 VIN.t631 VSS 0.00774f
C4154 VIN.t1773 VSS 0.00774f
C4155 VIN.t285 VSS 0.00774f
C4156 VIN.t1943 VSS 0.00774f
C4157 VIN.t1027 VSS 0.00774f
C4158 VIN.t99 VSS 0.00774f
C4159 VIN.t1189 VSS 0.00774f
C4160 VIN.t274 VSS 0.00774f
C4161 VIN.t1449 VSS 0.00774f
C4162 VIN.t469 VSS 0.00774f
C4163 VIN.t151 VSS 0.00774f
C4164 VIN.n42 VSS 0.0477f
C4165 VIN.t302 VSS 0.00774f
C4166 VIN.t253 VSS 0.00774f
C4167 VIN.n43 VSS 0.08749f
C4168 VIN.t1371 VSS 0.00774f
C4169 VIN.t1323 VSS 0.00774f
C4170 VIN.n44 VSS 0.08749f
C4171 VIN.t1075 VSS 0.00774f
C4172 VIN.t1029 VSS 0.00774f
C4173 VIN.n45 VSS 0.08749f
C4174 VIN.t1611 VSS 0.00774f
C4175 VIN.t1561 VSS 0.00774f
C4176 VIN.n46 VSS 0.08749f
C4177 VIN.t1241 VSS 0.00774f
C4178 VIN.t1197 VSS 0.00774f
C4179 VIN.n47 VSS 0.08749f
C4180 VIN.t344 VSS 0.00774f
C4181 VIN.t281 VSS 0.00774f
C4182 VIN.n48 VSS 0.08749f
C4183 VIN.t907 VSS 0.00774f
C4184 VIN.t845 VSS 0.00774f
C4185 VIN.n49 VSS 0.08749f
C4186 VIN.t517 VSS 0.00774f
C4187 VIN.t473 VSS 0.00774f
C4188 VIN.n50 VSS 0.08749f
C4189 VIN.t1351 VSS 0.00774f
C4190 VIN.t729 VSS 0.00774f
C4191 VIN.n51 VSS 0.08749f
C4192 VIN.t471 VSS 0.00774f
C4193 VIN.t1887 VSS 0.00774f
C4194 VIN.n52 VSS 0.08749f
C4195 VIN.t1487 VSS 0.00774f
C4196 VIN.t905 VSS 0.00774f
C4197 VIN.n53 VSS 0.08749f
C4198 VIN.t613 VSS 0.00774f
C4199 VIN.t2041 VSS 0.00774f
C4200 VIN.n54 VSS 0.08749f
C4201 VIN.t1759 VSS 0.00774f
C4202 VIN.t1179 VSS 0.00774f
C4203 VIN.n55 VSS 0.08749f
C4204 VIN.t775 VSS 0.00774f
C4205 VIN.t145 VSS 0.00774f
C4206 VIN.n56 VSS 0.08749f
C4207 VIN.t495 VSS 0.00774f
C4208 VIN.t1919 VSS 0.00774f
C4209 VIN.n57 VSS 0.11224f
C4210 VIN.n58 VSS 0.08159f
C4211 VIN.n59 VSS 0.05955f
C4212 VIN.t2121 VSS 0.00692f
C4213 VIN.t2118 VSS 0.00692f
C4214 VIN.n60 VSS 0.01918f
C4215 VIN.n61 VSS 0.06795f
C4216 VIN.n62 VSS 0.32879f
C4217 VIN.n63 VSS 0.05473f
C4218 VIN.n64 VSS 0.05473f
C4219 VIN.t2112 VSS 0.74354f
C4220 VIN.n65 VSS 0.08144f
C4221 VIN.n66 VSS 0.08144f
C4222 VIN.n67 VSS 0.45011f
C4223 VIN.n68 VSS 0.30345f
C4224 VIN.t2120 VSS 0.69476f
C4225 VIN.t2126 VSS 0.69476f
C4226 VIN.t2113 VSS 0.52107f
C4227 VIN.n69 VSS 0.34738f
C4228 VIN.t2115 VSS 0.52107f
C4229 VIN.t2124 VSS 0.69476f
C4230 VIN.t2122 VSS 0.69476f
C4231 VIN.t2114 VSS 0.74354f
C4232 VIN.n70 VSS 0.17065f
C4233 VIN.t2116 VSS 0.00692f
C4234 VIN.t2123 VSS 0.00692f
C4235 VIN.n71 VSS 0.01918f
C4236 VIN.n72 VSS 0.06795f
C4237 VIN.n73 VSS 0.08361f
C4238 VIN.n74 VSS 0.08506f
C4239 VIN.t2125 VSS 0.00692f
C4240 VIN.t2117 VSS 0.00692f
C4241 VIN.n75 VSS 0.01918f
C4242 VIN.n76 VSS 0.06939f
C4243 VIN.n77 VSS 0.29169f
C4244 VIN.n78 VSS 0.26099f
C4245 VIN.n79 VSS 0.24221f
C4246 VIN.t231 VSS 0.00774f
C4247 VIN.t799 VSS 0.00774f
C4248 VIN.t1841 VSS 0.00774f
C4249 VIN.t1543 VSS 0.00774f
C4250 VIN.t2111 VSS 0.00774f
C4251 VIN.t1715 VSS 0.00774f
C4252 VIN.t831 VSS 0.00774f
C4253 VIN.t1395 VSS 0.00774f
C4254 VIN.t1009 VSS 0.00774f
C4255 VIN.t939 VSS 0.00774f
C4256 VIN.t2095 VSS 0.00774f
C4257 VIN.t1105 VSS 0.00774f
C4258 VIN.t174 VSS 0.00774f
C4259 VIN.t1373 VSS 0.00774f
C4260 VIN.t365 VSS 0.00774f
C4261 VIN.t2 VSS 0.00774f
C4262 VIN.t1491 VSS 0.00774f
C4263 VIN.n80 VSS 0.10181f
C4264 VIN.t1787 VSS 0.00774f
C4265 VIN.n81 VSS 0.08863f
C4266 VIN.t751 VSS 0.00774f
C4267 VIN.n82 VSS 0.08863f
C4268 VIN.t1617 VSS 0.00774f
C4269 VIN.n83 VSS 0.08863f
C4270 VIN.t497 VSS 0.00774f
C4271 VIN.n84 VSS 0.08863f
C4272 VIN.t1475 VSS 0.00774f
C4273 VIN.n85 VSS 0.08863f
C4274 VIN.t320 VSS 0.00774f
C4275 VIN.n86 VSS 0.08863f
C4276 VIN.t953 VSS 0.00774f
C4277 VIN.n87 VSS 0.08863f
C4278 VIN.t1353 VSS 0.00774f
C4279 VIN.n88 VSS 0.08863f
C4280 VIN.t783 VSS 0.00774f
C4281 VIN.n89 VSS 0.08863f
C4282 VIN.t1673 VSS 0.00774f
C4283 VIN.n90 VSS 0.08863f
C4284 VIN.t2065 VSS 0.00774f
C4285 VIN.n91 VSS 0.08863f
C4286 VIN.t1493 VSS 0.00774f
C4287 VIN.n92 VSS 0.08863f
C4288 VIN.t1791 VSS 0.00774f
C4289 VIN.n93 VSS 0.08863f
C4290 VIN.t755 VSS 0.00774f
C4291 VIN.n94 VSS 0.08863f
C4292 VIN.t179 VSS 0.00774f
C4293 VIN.n95 VSS 0.0729f
C4294 VIN.n96 VSS 0.22248f
C4295 VIN.t230 VSS 0.00879f
C4296 VIN.n97 VSS 0.22953f
C4297 VIN.n98 VSS 0.3531f
C4298 VIN.n99 VSS 0.09688f
C4299 VIN.n100 VSS 0.38381f
C4300 VIN.t502 VSS 0.00879f
C4301 VIN.n101 VSS 0.22953f
C4302 VIN.n102 VSS 0.21493f
C4303 VIN.n103 VSS 0.33586f
C4304 VIN.t819 VSS 0.00774f
C4305 VIN.t1385 VSS 0.00774f
C4306 VIN.t385 VSS 0.00774f
C4307 VIN.t23 VSS 0.00774f
C4308 VIN.t633 VSS 0.00774f
C4309 VIN.t238 VSS 0.00774f
C4310 VIN.t1397 VSS 0.00774f
C4311 VIN.t1945 VSS 0.00774f
C4312 VIN.t1545 VSS 0.00774f
C4313 VIN.t1123 VSS 0.00774f
C4314 VIN.t214 VSS 0.00774f
C4315 VIN.t1297 VSS 0.00774f
C4316 VIN.t398 VSS 0.00774f
C4317 VIN.t1533 VSS 0.00774f
C4318 VIN.t563 VSS 0.00774f
C4319 VIN.t263 VSS 0.00774f
C4320 VIN.t354 VSS 0.00774f
C4321 VIN.n104 VSS 0.08171f
C4322 VIN.t637 VSS 0.00774f
C4323 VIN.n105 VSS 0.08749f
C4324 VIN.t1627 VSS 0.00774f
C4325 VIN.n106 VSS 0.08749f
C4326 VIN.t487 VSS 0.00774f
C4327 VIN.n107 VSS 0.08749f
C4328 VIN.t1387 VSS 0.00774f
C4329 VIN.n108 VSS 0.08749f
C4330 VIN.t329 VSS 0.00774f
C4331 VIN.n109 VSS 0.08749f
C4332 VIN.t1221 VSS 0.00774f
C4333 VIN.n110 VSS 0.08749f
C4334 VIN.t1299 VSS 0.00774f
C4335 VIN.n111 VSS 0.08749f
C4336 VIN.t1661 VSS 0.00774f
C4337 VIN.n112 VSS 0.08749f
C4338 VIN.t1131 VSS 0.00774f
C4339 VIN.n113 VSS 0.08749f
C4340 VIN.t2009 VSS 0.00774f
C4341 VIN.n114 VSS 0.08749f
C4342 VIN.t363 VSS 0.00774f
C4343 VIN.n115 VSS 0.08749f
C4344 VIN.t1839 VSS 0.00774f
C4345 VIN.n116 VSS 0.08749f
C4346 VIN.t38 VSS 0.00774f
C4347 VIN.n117 VSS 0.08749f
C4348 VIN.t1109 VSS 0.00774f
C4349 VIN.n118 VSS 0.08749f
C4350 VIN.t549 VSS 0.00774f
C4351 VIN.n119 VSS 0.07176f
C4352 VIN.n120 VSS 0.38381f
C4353 VIN.n121 VSS 0.13241f
C4354 VIN.n122 VSS 0.23028f
C4355 VIN.t1423 VSS 0.00774f
C4356 VIN.t1977 VSS 0.00774f
C4357 VIN.t993 VSS 0.00774f
C4358 VIN.t689 VSS 0.00774f
C4359 VIN.t1257 VSS 0.00774f
C4360 VIN.t861 VSS 0.00774f
C4361 VIN.t1997 VSS 0.00774f
C4362 VIN.t529 VSS 0.00774f
C4363 VIN.t88 VSS 0.00774f
C4364 VIN.t1797 VSS 0.00774f
C4365 VIN.t937 VSS 0.00774f
C4366 VIN.t1961 VSS 0.00774f
C4367 VIN.t1077 VSS 0.00774f
C4368 VIN.t176 VSS 0.00774f
C4369 VIN.t1247 VSS 0.00774f
C4370 VIN.t957 VSS 0.00774f
C4371 VIN.n123 VSS 0.04192f
C4372 VIN.n124 VSS 0.03975f
C4373 VIN.t2150 VSS 0.00692f
C4374 VIN.t2141 VSS 0.00692f
C4375 VIN.n125 VSS 0.01918f
C4376 VIN.n126 VSS 0.03542f
C4377 VIN.n127 VSS 0.03903f
C4378 VIN.n128 VSS 0.26099f
C4379 VIN.n129 VSS 0.42986f
C4380 VIN.n130 VSS 0.22606f
C4381 VIN.n131 VSS 0.23783f
C4382 VIN.t1654 VSS 0.00879f
C4383 VIN.n132 VSS 0.22953f
C4384 VIN.n133 VSS 0.3224f
C4385 VIN.n134 VSS 0.24867f
C4386 VIN.t1749 VSS 0.00774f
C4387 VIN.t1705 VSS 0.00774f
C4388 VIN.n135 VSS 0.07176f
C4389 VIN.n136 VSS 0.41451f
C4390 VIN.t2090 VSS 0.00879f
C4391 VIN.n137 VSS 0.18108f
C4392 VIN.n138 VSS 0.21493f
C4393 VIN.t2091 VSS 0.00774f
C4394 VIN.t603 VSS 0.00774f
C4395 VIN.t1631 VSS 0.00774f
C4396 VIN.t1367 VSS 0.00774f
C4397 VIN.t1909 VSS 0.00774f
C4398 VIN.t1503 VSS 0.00774f
C4399 VIN.t625 VSS 0.00774f
C4400 VIN.t1191 VSS 0.00774f
C4401 VIN.t789 VSS 0.00774f
C4402 VIN.t1181 VSS 0.00774f
C4403 VIN.t279 VSS 0.00774f
C4404 VIN.t1349 VSS 0.00774f
C4405 VIN.t455 VSS 0.00774f
C4406 VIN.t1587 VSS 0.00774f
C4407 VIN.t615 VSS 0.00774f
C4408 VIN.t318 VSS 0.00774f
C4409 VIN.n139 VSS 0.23028f
C4410 VIN.n140 VSS 0.26099f
C4411 VIN.n141 VSS 0.24221f
C4412 VIN.t272 VSS 0.00774f
C4413 VIN.t837 VSS 0.00774f
C4414 VIN.t1879 VSS 0.00774f
C4415 VIN.t1583 VSS 0.00774f
C4416 VIN.t59 VSS 0.00774f
C4417 VIN.t1751 VSS 0.00774f
C4418 VIN.t867 VSS 0.00774f
C4419 VIN.t1421 VSS 0.00774f
C4420 VIN.t1045 VSS 0.00774f
C4421 VIN.t841 VSS 0.00774f
C4422 VIN.t1989 VSS 0.00774f
C4423 VIN.t1017 VSS 0.00774f
C4424 VIN.t61 VSS 0.00774f
C4425 VIN.t1289 VSS 0.00774f
C4426 VIN.t267 VSS 0.00774f
C4427 VIN.t2035 VSS 0.00774f
C4428 VIN.t1595 VSS 0.00774f
C4429 VIN.n142 VSS 0.08284f
C4430 VIN.t1889 VSS 0.00774f
C4431 VIN.n143 VSS 0.08863f
C4432 VIN.t849 VSS 0.00774f
C4433 VIN.n144 VSS 0.08863f
C4434 VIN.t1717 VSS 0.00774f
C4435 VIN.n145 VSS 0.08863f
C4436 VIN.t579 VSS 0.00774f
C4437 VIN.n146 VSS 0.08863f
C4438 VIN.t1559 VSS 0.00774f
C4439 VIN.n147 VSS 0.08863f
C4440 VIN.t435 VSS 0.00774f
C4441 VIN.n148 VSS 0.08863f
C4442 VIN.t1447 VSS 0.00774f
C4443 VIN.n149 VSS 0.08863f
C4444 VIN.t1829 VSS 0.00774f
C4445 VIN.n150 VSS 0.08863f
C4446 VIN.t1293 VSS 0.00774f
C4447 VIN.n151 VSS 0.08863f
C4448 VIN.t96 VSS 0.00774f
C4449 VIN.n152 VSS 0.08863f
C4450 VIN.t537 VSS 0.00774f
C4451 VIN.n153 VSS 0.08863f
C4452 VIN.t2003 VSS 0.00774f
C4453 VIN.n154 VSS 0.08863f
C4454 VIN.t243 VSS 0.00774f
C4455 VIN.n155 VSS 0.08863f
C4456 VIN.t1263 VSS 0.00774f
C4457 VIN.n156 VSS 0.08863f
C4458 VIN.t693 VSS 0.00774f
C4459 VIN.n157 VSS 0.0729f
C4460 VIN.n158 VSS 0.22248f
C4461 VIN.t271 VSS 0.00879f
C4462 VIN.n159 VSS 0.22953f
C4463 VIN.n160 VSS 0.41451f
C4464 VIN.n161 VSS 0.16147f
C4465 VIN.n162 VSS 0.41451f
C4466 VIN.t998 VSS 0.00879f
C4467 VIN.n163 VSS 0.22953f
C4468 VIN.n164 VSS 0.21493f
C4469 VIN.n165 VSS 0.40045f
C4470 VIN.t1327 VSS 0.00774f
C4471 VIN.t1861 VSS 0.00774f
C4472 VIN.t869 VSS 0.00774f
C4473 VIN.t587 VSS 0.00774f
C4474 VIN.t1149 VSS 0.00774f
C4475 VIN.t745 VSS 0.00774f
C4476 VIN.t1893 VSS 0.00774f
C4477 VIN.t418 VSS 0.00774f
C4478 VIN.t2063 VSS 0.00774f
C4479 VIN.t1227 VSS 0.00774f
C4480 VIN.t340 VSS 0.00774f
C4481 VIN.t1393 VSS 0.00774f
C4482 VIN.t501 VSS 0.00774f
C4483 VIN.t1645 VSS 0.00774f
C4484 VIN.t651 VSS 0.00774f
C4485 VIN.t373 VSS 0.00774f
C4486 VIN.t1795 VSS 0.00774f
C4487 VIN.n166 VSS 0.08171f
C4488 VIN.t2093 VSS 0.00774f
C4489 VIN.n167 VSS 0.08749f
C4490 VIN.t1055 VSS 0.00774f
C4491 VIN.n168 VSS 0.08749f
C4492 VIN.t1925 VSS 0.00774f
C4493 VIN.n169 VSS 0.08749f
C4494 VIN.t779 VSS 0.00774f
C4495 VIN.n170 VSS 0.08749f
C4496 VIN.t1765 VSS 0.00774f
C4497 VIN.n171 VSS 0.08749f
C4498 VIN.t617 VSS 0.00774f
C4499 VIN.n172 VSS 0.08749f
C4500 VIN.t2007 VSS 0.00774f
C4501 VIN.n173 VSS 0.08749f
C4502 VIN.t361 VSS 0.00774f
C4503 VIN.n174 VSS 0.08749f
C4504 VIN.t1837 VSS 0.00774f
C4505 VIN.n175 VSS 0.08749f
C4506 VIN.t701 VSS 0.00774f
C4507 VIN.n176 VSS 0.08749f
C4508 VIN.t1107 VSS 0.00774f
C4509 VIN.n177 VSS 0.08749f
C4510 VIN.t545 VSS 0.00774f
C4511 VIN.n178 VSS 0.08749f
C4512 VIN.t825 VSS 0.00774f
C4513 VIN.n179 VSS 0.08749f
C4514 VIN.t1817 VSS 0.00774f
C4515 VIN.n180 VSS 0.08749f
C4516 VIN.t1275 VSS 0.00774f
C4517 VIN.n181 VSS 0.07176f
C4518 VIN.n182 VSS 0.41451f
C4519 VIN.n183 VSS 0.197f
C4520 VIN.t1233 VSS 0.00774f
C4521 VIN.t1771 VSS 0.00774f
C4522 VIN.t785 VSS 0.00774f
C4523 VIN.t511 VSS 0.00774f
C4524 VIN.t1071 VSS 0.00774f
C4525 VIN.t665 VSS 0.00774f
C4526 VIN.t1809 VSS 0.00774f
C4527 VIN.t325 VSS 0.00774f
C4528 VIN.t1979 VSS 0.00774f
C4529 VIN.t375 VSS 0.00774f
C4530 VIN.t1515 VSS 0.00774f
C4531 VIN.t543 VSS 0.00774f
C4532 VIN.t1667 VSS 0.00774f
C4533 VIN.t805 VSS 0.00774f
C4534 VIN.t1835 VSS 0.00774f
C4535 VIN.t1541 VSS 0.00774f
C4536 VIN.t461 VSS 0.00774f
C4537 VIN.n184 VSS 0.08228f
C4538 VIN.t731 VSS 0.00774f
C4539 VIN.n185 VSS 0.08806f
C4540 VIN.t1721 VSS 0.00774f
C4541 VIN.n186 VSS 0.08806f
C4542 VIN.t567 VSS 0.00774f
C4543 VIN.n187 VSS 0.08806f
C4544 VIN.t1451 VSS 0.00774f
C4545 VIN.n188 VSS 0.08806f
C4546 VIN.t424 VSS 0.00774f
C4547 VIN.n189 VSS 0.08806f
C4548 VIN.t1305 VSS 0.00774f
C4549 VIN.n190 VSS 0.08806f
C4550 VIN.t581 VSS 0.00774f
C4551 VIN.n191 VSS 0.08806f
C4552 VIN.t979 VSS 0.00774f
C4553 VIN.n192 VSS 0.08806f
C4554 VIN.t429 VSS 0.00774f
C4555 VIN.n193 VSS 0.08806f
C4556 VIN.t1325 VSS 0.00774f
C4557 VIN.n194 VSS 0.08806f
C4558 VIN.t1691 VSS 0.00774f
C4559 VIN.n195 VSS 0.08806f
C4560 VIN.t1153 VSS 0.00774f
C4561 VIN.n196 VSS 0.08806f
C4562 VIN.t1433 VSS 0.00774f
C4563 VIN.n197 VSS 0.08806f
C4564 VIN.t396 VSS 0.00774f
C4565 VIN.n198 VSS 0.08806f
C4566 VIN.t1867 VSS 0.00774f
C4567 VIN.n199 VSS 0.07233f
C4568 VIN.n200 VSS 0.42986f
C4569 VIN.t1534 VSS 0.00879f
C4570 VIN.n201 VSS 0.22953f
C4571 VIN.t1535 VSS 0.00774f
C4572 VIN.t2107 VSS 0.00774f
C4573 VIN.t1121 VSS 0.00774f
C4574 VIN.t829 VSS 0.00774f
C4575 VIN.t1391 VSS 0.00774f
C4576 VIN.t1005 VSS 0.00774f
C4577 VIN.t35 VSS 0.00774f
C4578 VIN.t657 VSS 0.00774f
C4579 VIN.t251 VSS 0.00774f
C4580 VIN.t895 VSS 0.00774f
C4581 VIN.t2049 VSS 0.00774f
C4582 VIN.t1067 VSS 0.00774f
C4583 VIN.t133 VSS 0.00774f
C4584 VIN.t1343 VSS 0.00774f
C4585 VIN.t327 VSS 0.00774f
C4586 VIN.t2085 VSS 0.00774f
C4587 VIN.t80 VSS 0.00774f
C4588 VIN.n202 VSS 0.08284f
C4589 VIN.t422 VSS 0.00774f
C4590 VIN.n203 VSS 0.08863f
C4591 VIN.t1407 VSS 0.00774f
C4592 VIN.n204 VSS 0.08863f
C4593 VIN.t220 VSS 0.00774f
C4594 VIN.n205 VSS 0.08863f
C4595 VIN.t1151 VSS 0.00774f
C4596 VIN.n206 VSS 0.08863f
C4597 VIN.t41 VSS 0.00774f
C4598 VIN.n207 VSS 0.08863f
C4599 VIN.t985 VSS 0.00774f
C4600 VIN.n208 VSS 0.08863f
C4601 VIN.t2023 VSS 0.00774f
C4602 VIN.n209 VSS 0.08863f
C4603 VIN.t383 VSS 0.00774f
C4604 VIN.n210 VSS 0.08863f
C4605 VIN.t1857 VSS 0.00774f
C4606 VIN.n211 VSS 0.08863f
C4607 VIN.t709 VSS 0.00774f
C4608 VIN.n212 VSS 0.08863f
C4609 VIN.t1117 VSS 0.00774f
C4610 VIN.n213 VSS 0.08863f
C4611 VIN.t555 VSS 0.00774f
C4612 VIN.n214 VSS 0.08863f
C4613 VIN.t833 VSS 0.00774f
C4614 VIN.n215 VSS 0.08863f
C4615 VIN.t1823 VSS 0.00774f
C4616 VIN.n216 VSS 0.08863f
C4617 VIN.t1285 VSS 0.00774f
C4618 VIN.n217 VSS 0.0729f
C4619 VIN.n218 VSS 0.21493f
C4620 VIN.n219 VSS 0.41983f
C4621 VIN.t70 VSS 0.00774f
C4622 VIN.t669 VSS 0.00774f
C4623 VIN.t1707 VSS 0.00774f
C4624 VIN.t1431 VSS 0.00774f
C4625 VIN.t1985 VSS 0.00774f
C4626 VIN.t1581 VSS 0.00774f
C4627 VIN.t703 VSS 0.00774f
C4628 VIN.t1271 VSS 0.00774f
C4629 VIN.t871 VSS 0.00774f
C4630 VIN.t1555 VSS 0.00774f
C4631 VIN.t687 VSS 0.00774f
C4632 VIN.t1725 VSS 0.00774f
C4633 VIN.t839 VSS 0.00774f
C4634 VIN.t1995 VSS 0.00774f
C4635 VIN.t1021 VSS 0.00774f
C4636 VIN.t725 VSS 0.00774f
C4637 VIN.t645 VSS 0.00774f
C4638 VIN.n220 VSS 0.08228f
C4639 VIN.t945 VSS 0.00774f
C4640 VIN.n221 VSS 0.08806f
C4641 VIN.t1935 VSS 0.00774f
C4642 VIN.n222 VSS 0.08806f
C4643 VIN.t769 VSS 0.00774f
C4644 VIN.n223 VSS 0.08806f
C4645 VIN.t1651 VSS 0.00774f
C4646 VIN.n224 VSS 0.08806f
C4647 VIN.t619 VSS 0.00774f
C4648 VIN.n225 VSS 0.08806f
C4649 VIN.t1483 VSS 0.00774f
C4650 VIN.n226 VSS 0.08806f
C4651 VIN.t299 VSS 0.00774f
C4652 VIN.n227 VSS 0.08806f
C4653 VIN.t699 VSS 0.00774f
C4654 VIN.n228 VSS 0.08806f
C4655 VIN.t104 VSS 0.00774f
C4656 VIN.n229 VSS 0.08806f
C4657 VIN.t1053 VSS 0.00774f
C4658 VIN.n230 VSS 0.08806f
C4659 VIN.t1425 VSS 0.00774f
C4660 VIN.n231 VSS 0.08806f
C4661 VIN.t873 VSS 0.00774f
C4662 VIN.n232 VSS 0.08806f
C4663 VIN.t1177 VSS 0.00774f
C4664 VIN.n233 VSS 0.08806f
C4665 VIN.t67 VSS 0.00774f
C4666 VIN.n234 VSS 0.08806f
C4667 VIN.t1585 VSS 0.00774f
C4668 VIN.n235 VSS 0.07233f
C4669 VIN.n236 VSS 0.3224f
C4670 VIN.n237 VSS 0.31326f
C4671 VIN.t199 VSS 0.00774f
C4672 VIN.t773 VSS 0.00774f
C4673 VIN.t1813 VSS 0.00774f
C4674 VIN.t1509 VSS 0.00774f
C4675 VIN.t2083 VSS 0.00774f
C4676 VIN.t1681 VSS 0.00774f
C4677 VIN.t797 VSS 0.00774f
C4678 VIN.t1365 VSS 0.00774f
C4679 VIN.t965 VSS 0.00774f
C4680 VIN.t739 VSS 0.00774f
C4681 VIN.t1901 VSS 0.00774f
C4682 VIN.t917 VSS 0.00774f
C4683 VIN.t2055 VSS 0.00774f
C4684 VIN.t1185 VSS 0.00774f
C4685 VIN.t165 VSS 0.00774f
C4686 VIN.t1941 VSS 0.00774f
C4687 VIN.t1345 VSS 0.00774f
C4688 VIN.n238 VSS 0.08171f
C4689 VIN.t1605 VSS 0.00774f
C4690 VIN.n239 VSS 0.08749f
C4691 VIN.t575 VSS 0.00774f
C4692 VIN.n240 VSS 0.08749f
C4693 VIN.t1443 VSS 0.00774f
C4694 VIN.n241 VSS 0.08749f
C4695 VIN.t289 VSS 0.00774f
C4696 VIN.n242 VSS 0.08749f
C4697 VIN.t1315 VSS 0.00774f
C4698 VIN.n243 VSS 0.08749f
C4699 VIN.t102 VSS 0.00774f
C4700 VIN.n244 VSS 0.08749f
C4701 VIN.t931 VSS 0.00774f
C4702 VIN.n245 VSS 0.08749f
C4703 VIN.t1321 VSS 0.00774f
C4704 VIN.n246 VSS 0.08749f
C4705 VIN.t747 VSS 0.00774f
C4706 VIN.n247 VSS 0.08749f
C4707 VIN.t1639 VSS 0.00774f
C4708 VIN.n248 VSS 0.08749f
C4709 VIN.t2039 VSS 0.00774f
C4710 VIN.n249 VSS 0.08749f
C4711 VIN.t1471 VSS 0.00774f
C4712 VIN.n250 VSS 0.08749f
C4713 VIN.t1757 VSS 0.00774f
C4714 VIN.n251 VSS 0.08749f
C4715 VIN.t723 VSS 0.00774f
C4716 VIN.n252 VSS 0.08749f
C4717 VIN.t149 VSS 0.00774f
C4718 VIN.n253 VSS 0.07176f
C4719 VIN.n254 VSS 0.42986f
C4720 VIN.n255 VSS 0.20669f
C4721 VIN.t547 VSS 0.00774f
C4722 VIN.t1111 VSS 0.00774f
C4723 VIN.t44 VSS 0.00774f
C4724 VIN.t1849 VSS 0.00774f
C4725 VIN.t369 VSS 0.00774f
C4726 VIN.t2013 VSS 0.00774f
C4727 VIN.t1129 VSS 0.00774f
C4728 VIN.t1671 VSS 0.00774f
C4729 VIN.t1307 VSS 0.00774f
C4730 VIN.t1273 VSS 0.00774f
C4731 VIN.t393 VSS 0.00774f
C4732 VIN.t1427 VSS 0.00774f
C4733 VIN.t541 VSS 0.00774f
C4734 VIN.t1685 VSS 0.00774f
C4735 VIN.t695 VSS 0.00774f
C4736 VIN.t431 VSS 0.00774f
C4737 VIN.t1843 VSS 0.00774f
C4738 VIN.n256 VSS 0.08171f
C4739 VIN.t29 VSS 0.00774f
C4740 VIN.n257 VSS 0.08749f
C4741 VIN.t1103 VSS 0.00774f
C4742 VIN.n258 VSS 0.08749f
C4743 VIN.t1965 VSS 0.00774f
C4744 VIN.n259 VSS 0.08749f
C4745 VIN.t827 VSS 0.00774f
C4746 VIN.n260 VSS 0.08749f
C4747 VIN.t1819 VSS 0.00774f
C4748 VIN.n261 VSS 0.08749f
C4749 VIN.t659 VSS 0.00774f
C4750 VIN.n262 VSS 0.08749f
C4751 VIN.t1249 VSS 0.00774f
C4752 VIN.n263 VSS 0.08749f
C4753 VIN.t1621 VSS 0.00774f
C4754 VIN.n264 VSS 0.08749f
C4755 VIN.t1079 VSS 0.00774f
C4756 VIN.n265 VSS 0.08749f
C4757 VIN.t1969 VSS 0.00774f
C4758 VIN.n266 VSS 0.08749f
C4759 VIN.t311 VSS 0.00774f
C4760 VIN.n267 VSS 0.08749f
C4761 VIN.t1799 VSS 0.00774f
C4762 VIN.n268 VSS 0.08749f
C4763 VIN.t2099 VSS 0.00774f
C4764 VIN.n269 VSS 0.08749f
C4765 VIN.t1063 VSS 0.00774f
C4766 VIN.n270 VSS 0.08749f
C4767 VIN.t507 VSS 0.00774f
C4768 VIN.n271 VSS 0.07176f
C4769 VIN.n272 VSS 0.42986f
C4770 VIN.t466 VSS 0.00879f
C4771 VIN.n273 VSS 0.22953f
C4772 VIN.t467 VSS 0.00774f
C4773 VIN.t1019 VSS 0.00774f
C4774 VIN.t2059 VSS 0.00774f
C4775 VIN.t1763 VSS 0.00774f
C4776 VIN.t270 VSS 0.00774f
C4777 VIN.t1937 VSS 0.00774f
C4778 VIN.t1049 VSS 0.00774f
C4779 VIN.t1579 VSS 0.00774f
C4780 VIN.t1223 VSS 0.00774f
C4781 VIN.t433 VSS 0.00774f
C4782 VIN.t1563 VSS 0.00774f
C4783 VIN.t583 VSS 0.00774f
C4784 VIN.t1719 VSS 0.00774f
C4785 VIN.t851 VSS 0.00774f
C4786 VIN.t1891 VSS 0.00774f
C4787 VIN.t1597 VSS 0.00774f
C4788 VIN.t1013 VSS 0.00774f
C4789 VIN.n274 VSS 0.08228f
C4790 VIN.t1303 VSS 0.00774f
C4791 VIN.n275 VSS 0.08806f
C4792 VIN.t224 VSS 0.00774f
C4793 VIN.n276 VSS 0.08806f
C4794 VIN.t1127 VSS 0.00774f
C4795 VIN.n277 VSS 0.08806f
C4796 VIN.t2011 VSS 0.00774f
C4797 VIN.n278 VSS 0.08806f
C4798 VIN.t983 VSS 0.00774f
C4799 VIN.n279 VSS 0.08806f
C4800 VIN.t1845 VSS 0.00774f
C4801 VIN.n280 VSS 0.08806f
C4802 VIN.t1173 VSS 0.00774f
C4803 VIN.n281 VSS 0.08806f
C4804 VIN.t1531 VSS 0.00774f
C4805 VIN.n282 VSS 0.08806f
C4806 VIN.t1003 VSS 0.00774f
C4807 VIN.n283 VSS 0.08806f
C4808 VIN.t1883 VSS 0.00774f
C4809 VIN.n284 VSS 0.08806f
C4810 VIN.t212 VSS 0.00774f
C4811 VIN.n285 VSS 0.08806f
C4812 VIN.t1709 VSS 0.00774f
C4813 VIN.n286 VSS 0.08806f
C4814 VIN.t1999 VSS 0.00774f
C4815 VIN.n287 VSS 0.08806f
C4816 VIN.t967 VSS 0.00774f
C4817 VIN.n288 VSS 0.08806f
C4818 VIN.t410 VSS 0.00774f
C4819 VIN.n289 VSS 0.07233f
C4820 VIN.n290 VSS 0.23028f
C4821 VIN.n291 VSS 0.42952f
C4822 VIN.t391 VSS 0.00774f
C4823 VIN.t949 VSS 0.00774f
C4824 VIN.t1983 VSS 0.00774f
C4825 VIN.t1683 VSS 0.00774f
C4826 VIN.t186 VSS 0.00774f
C4827 VIN.t1859 VSS 0.00774f
C4828 VIN.t971 VSS 0.00774f
C4829 VIN.t1499 VSS 0.00774f
C4830 VIN.t1141 VSS 0.00774f
C4831 VIN.t1337 VSS 0.00774f
C4832 VIN.t463 VSS 0.00774f
C4833 VIN.t1477 VSS 0.00774f
C4834 VIN.t597 VSS 0.00774f
C4835 VIN.t1745 VSS 0.00774f
C4836 VIN.t757 VSS 0.00774f
C4837 VIN.t491 VSS 0.00774f
C4838 VIN.t1915 VSS 0.00774f
C4839 VIN.n292 VSS 0.08284f
C4840 VIN.t117 VSS 0.00774f
C4841 VIN.n293 VSS 0.08863f
C4842 VIN.t1159 VSS 0.00774f
C4843 VIN.n294 VSS 0.08863f
C4844 VIN.t2029 VSS 0.00774f
C4845 VIN.n295 VSS 0.08863f
C4846 VIN.t887 VSS 0.00774f
C4847 VIN.n296 VSS 0.08863f
C4848 VIN.t1871 VSS 0.00774f
C4849 VIN.n297 VSS 0.08863f
C4850 VIN.t713 VSS 0.00774f
C4851 VIN.n298 VSS 0.08863f
C4852 VIN.t1095 VSS 0.00774f
C4853 VIN.n299 VSS 0.08863f
C4854 VIN.t1463 VSS 0.00774f
C4855 VIN.n300 VSS 0.08863f
C4856 VIN.t933 VSS 0.00774f
C4857 VIN.n301 VSS 0.08863f
C4858 VIN.t1811 VSS 0.00774f
C4859 VIN.n302 VSS 0.08863f
C4860 VIN.t122 VSS 0.00774f
C4861 VIN.n303 VSS 0.08863f
C4862 VIN.t1641 VSS 0.00774f
C4863 VIN.n304 VSS 0.08863f
C4864 VIN.t1939 VSS 0.00774f
C4865 VIN.n305 VSS 0.08863f
C4866 VIN.t899 VSS 0.00774f
C4867 VIN.n306 VSS 0.08863f
C4868 VIN.t337 VSS 0.00774f
C4869 VIN.n307 VSS 0.0729f
C4870 VIN.n308 VSS 0.42986f
C4871 VIN.n309 VSS 0.22606f
C4872 VIN.t1001 VSS 0.00774f
C4873 VIN.t1527 VSS 0.00774f
C4874 VIN.t557 VSS 0.00774f
C4875 VIN.t247 VSS 0.00774f
C4876 VIN.t823 VSS 0.00774f
C4877 VIN.t443 VSS 0.00774f
C4878 VIN.t1557 VSS 0.00774f
C4879 VIN.t14 VSS 0.00774f
C4880 VIN.t1731 VSS 0.00774f
C4881 VIN.t1991 VSS 0.00774f
C4882 VIN.t1137 VSS 0.00774f
C4883 VIN.t85 VSS 0.00774f
C4884 VIN.t1287 VSS 0.00774f
C4885 VIN.t406 VSS 0.00774f
C4886 VIN.t1439 VSS 0.00774f
C4887 VIN.t1169 VSS 0.00774f
C4888 VIN.t1091 VSS 0.00774f
C4889 VIN.n310 VSS 0.08228f
C4890 VIN.t1381 VSS 0.00774f
C4891 VIN.n311 VSS 0.08806f
C4892 VIN.t316 VSS 0.00774f
C4893 VIN.n312 VSS 0.08806f
C4894 VIN.t1213 VSS 0.00774f
C4895 VIN.n313 VSS 0.08806f
C4896 VIN.t2101 VSS 0.00774f
C4897 VIN.n314 VSS 0.08806f
C4898 VIN.t1065 VSS 0.00774f
C4899 VIN.n315 VSS 0.08806f
C4900 VIN.t1929 VSS 0.00774f
C4901 VIN.n316 VSS 0.08806f
C4902 VIN.t1187 VSS 0.00774f
C4903 VIN.n317 VSS 0.08806f
C4904 VIN.t1549 VSS 0.00774f
C4905 VIN.n318 VSS 0.08806f
C4906 VIN.t1023 VSS 0.00774f
C4907 VIN.n319 VSS 0.08806f
C4908 VIN.t1907 VSS 0.00774f
C4909 VIN.n320 VSS 0.08806f
C4910 VIN.t241 VSS 0.00774f
C4911 VIN.n321 VSS 0.08806f
C4912 VIN.t1735 VSS 0.00774f
C4913 VIN.n322 VSS 0.08806f
C4914 VIN.t2027 VSS 0.00774f
C4915 VIN.n323 VSS 0.08806f
C4916 VIN.t997 VSS 0.00774f
C4917 VIN.n324 VSS 0.08806f
C4918 VIN.t453 VSS 0.00774f
C4919 VIN.n325 VSS 0.07233f
C4920 VIN.n326 VSS 0.42986f
C4921 VIN.n327 VSS 0.23252f
C4922 VIN.t1333 VSS 0.00774f
C4923 VIN.t1863 VSS 0.00774f
C4924 VIN.t875 VSS 0.00774f
C4925 VIN.t585 VSS 0.00774f
C4926 VIN.t1147 VSS 0.00774f
C4927 VIN.t749 VSS 0.00774f
C4928 VIN.t1897 VSS 0.00774f
C4929 VIN.t427 VSS 0.00774f
C4930 VIN.t2061 VSS 0.00774f
C4931 VIN.t499 VSS 0.00774f
C4932 VIN.t1637 VSS 0.00774f
C4933 VIN.t653 VSS 0.00774f
C4934 VIN.t1783 VSS 0.00774f
C4935 VIN.t929 VSS 0.00774f
C4936 VIN.t1955 VSS 0.00774f
C4937 VIN.t1659 VSS 0.00774f
C4938 VIN.t1753 VSS 0.00774f
C4939 VIN.n328 VSS 0.08171f
C4940 VIN.t2047 VSS 0.00774f
C4941 VIN.n329 VSS 0.08749f
C4942 VIN.t1015 VSS 0.00774f
C4943 VIN.n330 VSS 0.08749f
C4944 VIN.t1875 VSS 0.00774f
C4945 VIN.n331 VSS 0.08749f
C4946 VIN.t733 VSS 0.00774f
C4947 VIN.n332 VSS 0.08749f
C4948 VIN.t1723 VSS 0.00774f
C4949 VIN.n333 VSS 0.08749f
C4950 VIN.t571 VSS 0.00774f
C4951 VIN.n334 VSS 0.08749f
C4952 VIN.t1775 VSS 0.00774f
C4953 VIN.n335 VSS 0.08749f
C4954 VIN.t93 VSS 0.00774f
C4955 VIN.n336 VSS 0.08749f
C4956 VIN.t1607 VSS 0.00774f
C4957 VIN.n337 VSS 0.08749f
C4958 VIN.t483 VSS 0.00774f
C4959 VIN.n338 VSS 0.08749f
C4960 VIN.t865 VSS 0.00774f
C4961 VIN.n339 VSS 0.08749f
C4962 VIN.t295 VSS 0.00774f
C4963 VIN.n340 VSS 0.08749f
C4964 VIN.t595 VSS 0.00774f
C4965 VIN.n341 VSS 0.08749f
C4966 VIN.t1577 VSS 0.00774f
C4967 VIN.n342 VSS 0.08749f
C4968 VIN.t1047 VSS 0.00774f
C4969 VIN.n343 VSS 0.07176f
C4970 VIN.n344 VSS 0.19958f
C4971 VIN.n345 VSS 0.23898f
C4972 VIN.t719 VSS 0.00774f
C4973 VIN.t1281 VSS 0.00774f
C4974 VIN.t265 VSS 0.00774f
C4975 VIN.t2025 VSS 0.00774f
C4976 VIN.t553 VSS 0.00774f
C4977 VIN.t120 VSS 0.00774f
C4978 VIN.t1317 VSS 0.00774f
C4979 VIN.t1853 VSS 0.00774f
C4980 VIN.t1455 VSS 0.00774f
C4981 VIN.t147 VSS 0.00774f
C4982 VIN.t1347 VSS 0.00774f
C4983 VIN.t335 VSS 0.00774f
C4984 VIN.t1473 VSS 0.00774f
C4985 VIN.t605 VSS 0.00774f
C4986 VIN.t1647 VSS 0.00774f
C4987 VIN.t1375 VSS 0.00774f
C4988 VIN.t753 VSS 0.00774f
C4989 VIN.n346 VSS 0.08171f
C4990 VIN.t1057 VSS 0.00774f
C4991 VIN.n347 VSS 0.08749f
C4992 VIN.t2033 VSS 0.00774f
C4993 VIN.n348 VSS 0.08749f
C4994 VIN.t877 VSS 0.00774f
C4995 VIN.n349 VSS 0.08749f
C4996 VIN.t1761 VSS 0.00774f
C4997 VIN.n350 VSS 0.08749f
C4998 VIN.t727 VSS 0.00774f
C4999 VIN.n351 VSS 0.08749f
C5000 VIN.t1589 VSS 0.00774f
C5001 VIN.n352 VSS 0.08749f
C5002 VIN.t1419 VSS 0.00774f
C5003 VIN.n353 VSS 0.08749f
C5004 VIN.t1805 VSS 0.00774f
C5005 VIN.n354 VSS 0.08749f
C5006 VIN.t1267 VSS 0.00774f
C5007 VIN.n355 VSS 0.08749f
C5008 VIN.t56 VSS 0.00774f
C5009 VIN.n356 VSS 0.08749f
C5010 VIN.t509 VSS 0.00774f
C5011 VIN.n357 VSS 0.08749f
C5012 VIN.t1981 VSS 0.00774f
C5013 VIN.n358 VSS 0.08749f
C5014 VIN.t209 VSS 0.00774f
C5015 VIN.n359 VSS 0.08749f
C5016 VIN.t1231 VSS 0.00774f
C5017 VIN.n360 VSS 0.08749f
C5018 VIN.t667 VSS 0.00774f
C5019 VIN.n361 VSS 0.07176f
C5020 VIN.n362 VSS 0.23783f
C5021 VIN.n363 VSS 0.21493f
C5022 VIN.n364 VSS 0.3531f
C5023 VIN.n365 VSS 0.24544f
C5024 VIN.t1339 VSS 0.00774f
C5025 VIN.t1873 VSS 0.00774f
C5026 VIN.t889 VSS 0.00774f
C5027 VIN.t601 VSS 0.00774f
C5028 VIN.t1163 VSS 0.00774f
C5029 VIN.t765 VSS 0.00774f
C5030 VIN.t1905 VSS 0.00774f
C5031 VIN.t441 VSS 0.00774f
C5032 VIN.t2069 VSS 0.00774f
C5033 VIN.t853 VSS 0.00774f
C5034 VIN.t2001 VSS 0.00774f
C5035 VIN.t1025 VSS 0.00774f
C5036 VIN.t73 VSS 0.00774f
C5037 VIN.t1295 VSS 0.00774f
C5038 VIN.t276 VSS 0.00774f
C5039 VIN.t2045 VSS 0.00774f
C5040 VIN.t1437 VSS 0.00774f
C5041 VIN.n366 VSS 0.08228f
C5042 VIN.t1713 VSS 0.00774f
C5043 VIN.n367 VSS 0.08806f
C5044 VIN.t673 VSS 0.00774f
C5045 VIN.n368 VSS 0.08806f
C5046 VIN.t1537 VSS 0.00774f
C5047 VIN.n369 VSS 0.08806f
C5048 VIN.t412 VSS 0.00774f
C5049 VIN.n370 VSS 0.08806f
C5050 VIN.t1403 VSS 0.00774f
C5051 VIN.n371 VSS 0.08806f
C5052 VIN.t229 VSS 0.00774f
C5053 VIN.n372 VSS 0.08806f
C5054 VIN.t2021 VSS 0.00774f
C5055 VIN.n373 VSS 0.08806f
C5056 VIN.t387 VSS 0.00774f
C5057 VIN.n374 VSS 0.08806f
C5058 VIN.t1855 VSS 0.00774f
C5059 VIN.n375 VSS 0.08806f
C5060 VIN.t715 VSS 0.00774f
C5061 VIN.n376 VSS 0.08806f
C5062 VIN.t1119 VSS 0.00774f
C5063 VIN.n377 VSS 0.08806f
C5064 VIN.t561 VSS 0.00774f
C5065 VIN.n378 VSS 0.08806f
C5066 VIN.t835 VSS 0.00774f
C5067 VIN.n379 VSS 0.08806f
C5068 VIN.t1825 VSS 0.00774f
C5069 VIN.n380 VSS 0.08806f
C5070 VIN.t1283 VSS 0.00774f
C5071 VIN.n381 VSS 0.07233f
C5072 VIN.n382 VSS 0.29169f
C5073 VIN.t1648 VSS 0.00879f
C5074 VIN.n383 VSS 0.05191f
C5075 VIN.n384 VSS 0.38381f
C5076 VIN.n385 VSS 0.25836f
C5077 VIN.t197 VSS 0.00774f
C5078 VIN.t777 VSS 0.00774f
C5079 VIN.t1815 VSS 0.00774f
C5080 VIN.t1513 VSS 0.00774f
C5081 VIN.t2089 VSS 0.00774f
C5082 VIN.t1689 VSS 0.00774f
C5083 VIN.t795 VSS 0.00774f
C5084 VIN.t1363 VSS 0.00774f
C5085 VIN.t969 VSS 0.00774f
C5086 VIN.t2053 VSS 0.00774f
C5087 VIN.t1183 VSS 0.00774f
C5088 VIN.t159 VSS 0.00774f
C5089 VIN.t1341 VSS 0.00774f
C5090 VIN.t459 VSS 0.00774f
C5091 VIN.t1481 VSS 0.00774f
C5092 VIN.t1219 VSS 0.00774f
C5093 VIN.t1135 VSS 0.00774f
C5094 VIN.n386 VSS 0.08228f
C5095 VIN.t1411 VSS 0.00774f
C5096 VIN.n387 VSS 0.08806f
C5097 VIN.t371 VSS 0.00774f
C5098 VIN.n388 VSS 0.08806f
C5099 VIN.t1259 VSS 0.00774f
C5100 VIN.n389 VSS 0.08806f
C5101 VIN.t47 VSS 0.00774f
C5102 VIN.n390 VSS 0.08806f
C5103 VIN.t1113 VSS 0.00774f
C5104 VIN.n391 VSS 0.08806f
C5105 VIN.t1975 VSS 0.00774f
C5106 VIN.n392 VSS 0.08806f
C5107 VIN.t416 VSS 0.00774f
C5108 VIN.n393 VSS 0.08806f
C5109 VIN.t793 VSS 0.00774f
C5110 VIN.n394 VSS 0.08806f
C5111 VIN.t216 VSS 0.00774f
C5112 VIN.n395 VSS 0.08806f
C5113 VIN.t1143 VSS 0.00774f
C5114 VIN.n396 VSS 0.08806f
C5115 VIN.t1507 VSS 0.00774f
C5116 VIN.n397 VSS 0.08806f
C5117 VIN.t973 VSS 0.00774f
C5118 VIN.n398 VSS 0.08806f
C5119 VIN.t1269 VSS 0.00774f
C5120 VIN.n399 VSS 0.08806f
C5121 VIN.t195 VSS 0.00774f
C5122 VIN.n400 VSS 0.08806f
C5123 VIN.t1693 VSS 0.00774f
C5124 VIN.n401 VSS 0.07233f
C5125 VIN.n402 VSS 0.15701f
C5126 VIN.n403 VSS 0.05768f
C5127 VIN.n404 VSS 0.16595f
C5128 VIN.t194 VSS 0.00882f
C5129 VIN.t62 VSS 0.00882f
C5130 VIN.t1824 VSS 0.00882f
C5131 VIN.t1230 VSS 0.00882f
C5132 VIN.t1576 VSS 0.00882f
C5133 VIN.t996 VSS 0.00882f
C5134 VIN.t898 VSS 0.00882f
C5135 VIN.t966 VSS 0.00882f
C5136 VIN.t1062 VSS 0.00882f
C5137 VIN.t722 VSS 0.00882f
C5138 VIN.t65 VSS 0.00882f
C5139 VIN.t1822 VSS 0.00882f
C5140 VIN.t394 VSS 0.00882f
C5141 VIN.t1816 VSS 0.00882f
C5142 VIN.t1484 VSS 0.00882f
C5143 VIN.t890 VSS 0.00882f
C5144 VIN.t1262 VSS 0.00882f
C5145 VIN.t1166 VSS 0.00882f
C5146 VIN.t312 VSS 0.00882f
C5147 VIN.t202 VSS 0.00882f
C5148 VIN.t296 VSS 0.00882f
C5149 VIN.t2018 VSS 0.00882f
C5150 VIN.t1932 VSS 0.00882f
C5151 VIN.t1108 VSS 0.00882f
C5152 VIN.t1006 VSS 0.00882f
C5153 VIN.t846 VSS 0.00882f
C5154 VIN.t754 VSS 0.00882f
C5155 VIN.t662 VSS 0.00882f
C5156 VIN.t1700 VSS 0.00882f
C5157 VIN.t252 VSS 0.00882f
C5158 VIN.t1566 VSS 0.00882f
C5159 VIN.t1662 VSS 0.00882f
C5160 VIN.t1132 VSS 0.00879f
C5161 VIN.n405 VSS 0.04485f
C5162 VIN.t1038 VSS 0.00879f
C5163 VIN.n406 VSS 0.06914f
C5164 VIN.t1736 VSS 0.00879f
C5165 VIN.n407 VSS 0.06914f
C5166 VIN.t1164 VSS 0.00879f
C5167 VIN.n408 VSS 0.06914f
C5168 VIN.t48 VSS 0.00879f
C5169 VIN.n409 VSS 0.06914f
C5170 VIN.t177 VSS 0.00879f
C5171 VIN.n410 VSS 0.06914f
C5172 VIN.t282 VSS 0.00879f
C5173 VIN.n411 VSS 0.06914f
C5174 VIN.t456 VSS 0.00879f
C5175 VIN.n412 VSS 0.06914f
C5176 VIN.t548 VSS 0.00879f
C5177 VIN.n413 VSS 0.06914f
C5178 VIN.t1388 VSS 0.00879f
C5179 VIN.n414 VSS 0.06914f
C5180 VIN.t1458 VSS 0.00879f
C5181 VIN.n415 VSS 0.06914f
C5182 VIN.t1780 VSS 0.00879f
C5183 VIN.n416 VSS 0.06914f
C5184 VIN.t1704 VSS 0.00879f
C5185 VIN.n417 VSS 0.06914f
C5186 VIN.t1800 VSS 0.00879f
C5187 VIN.n418 VSS 0.06914f
C5188 VIN.t610 VSS 0.00879f
C5189 VIN.n419 VSS 0.06914f
C5190 VIN.t692 VSS 0.00879f
C5191 VIN.n420 VSS 0.06914f
C5192 VIN.t332 VSS 0.00879f
C5193 VIN.n421 VSS 0.06914f
C5194 VIN.t950 VSS 0.00879f
C5195 VIN.n422 VSS 0.06914f
C5196 VIN.t1274 VSS 0.00879f
C5197 VIN.n423 VSS 0.06914f
C5198 VIN.t1866 VSS 0.00879f
C5199 VIN.n424 VSS 0.06914f
C5200 VIN.t1284 VSS 0.00879f
C5201 VIN.n425 VSS 0.06914f
C5202 VIN.t1584 VSS 0.00879f
C5203 VIN.n426 VSS 0.06914f
C5204 VIN.t148 VSS 0.00879f
C5205 VIN.n427 VSS 0.06914f
C5206 VIN.t506 VSS 0.00879f
C5207 VIN.n428 VSS 0.06914f
C5208 VIN.t409 VSS 0.00879f
C5209 VIN.n429 VSS 0.06914f
C5210 VIN.t336 VSS 0.00879f
C5211 VIN.n430 VSS 0.06914f
C5212 VIN.t452 VSS 0.00879f
C5213 VIN.n431 VSS 0.06914f
C5214 VIN.t1046 VSS 0.00879f
C5215 VIN.n432 VSS 0.06914f
C5216 VIN.t666 VSS 0.00879f
C5217 VIN.n433 VSS 0.06914f
C5218 VIN.t1282 VSS 0.00879f
C5219 VIN.n434 VSS 0.06914f
C5220 VIN.t1590 VSS 0.00879f
C5221 VIN.n435 VSS 0.06914f
C5222 VIN.t1692 VSS 0.00879f
C5223 VIN.n436 VSS 0.08056f
C5224 VIN.n437 VSS 0.08457f
C5225 VIN.t776 VSS 0.00881f
C5226 VIN.t1814 VSS 0.0088f
C5227 VIN.t140 VSS 0.00881f
C5228 VIN.t1224 VSS 0.0088f
C5229 VIN.t1872 VSS 0.00881f
C5230 VIN.t888 VSS 0.0088f
C5231 VIN.t1280 VSS 0.00881f
C5232 VIN.t264 VSS 0.0088f
C5233 VIN.t1862 VSS 0.00881f
C5234 VIN.t874 VSS 0.0088f
C5235 VIN.t1526 VSS 0.00881f
C5236 VIN.t556 VSS 0.0088f
C5237 VIN.t948 VSS 0.00881f
C5238 VIN.t1982 VSS 0.0088f
C5239 VIN.t1018 VSS 0.00881f
C5240 VIN.t2058 VSS 0.0088f
C5241 VIN.t1110 VSS 0.00881f
C5242 VIN.t42 VSS 0.0088f
C5243 VIN.t772 VSS 0.00881f
C5244 VIN.t1812 VSS 0.0088f
C5245 VIN.t668 VSS 0.00881f
C5246 VIN.t1706 VSS 0.0088f
C5247 VIN.t2106 VSS 0.00881f
C5248 VIN.t1120 VSS 0.0088f
C5249 VIN.t1770 VSS 0.00881f
C5250 VIN.t784 VSS 0.0088f
C5251 VIN.t1860 VSS 0.00881f
C5252 VIN.t868 VSS 0.0088f
C5253 VIN.t1528 VSS 0.00881f
C5254 VIN.t558 VSS 0.0088f
C5255 VIN.t1440 VSS 0.00881f
C5256 VIN.t464 VSS 0.0088f
C5257 VIN.t836 VSS 0.00881f
C5258 VIN.t1878 VSS 0.0088f
C5259 VIN.t1216 VSS 0.00881f
C5260 VIN.t187 VSS 0.0088f
C5261 VIN.t602 VSS 0.00881f
C5262 VIN.t1630 VSS 0.0088f
C5263 VIN.t260 VSS 0.00881f
C5264 VIN.t1330 VSS 0.0088f
C5265 VIN.t154 VSS 0.00881f
C5266 VIN.t1228 VSS 0.0088f
C5267 VIN.t2066 VSS 0.00881f
C5268 VIN.t1082 VSS 0.0088f
C5269 VIN.t1976 VSS 0.00881f
C5270 VIN.t992 VSS 0.0088f
C5271 VIN.t1384 VSS 0.00881f
C5272 VIN.t384 VSS 0.0088f
C5273 VIN.t1058 VSS 0.00881f
C5274 VIN.t2096 VSS 0.0088f
C5275 VIN.t1632 VSS 0.00881f
C5276 VIN.t642 VSS 0.0088f
C5277 VIN.t798 VSS 0.00881f
C5278 VIN.t1840 VSS 0.0088f
C5279 VIN.t704 VSS 0.00881f
C5280 VIN.t1740 VSS 0.0088f
C5281 VIN.t1742 VSS 0.00881f
C5282 VIN.t760 VSS 0.0088f
C5283 VIN.t300 VSS 0.00881f
C5284 VIN.t1370 VSS 0.0088f
C5285 VIN.t1488 VSS 0.00881f
C5286 VIN.t520 VSS 0.0088f
C5287 VIN.t1614 VSS 0.00881f
C5288 VIN.t626 VSS 0.0088f
C5289 VIN.n438 VSS 0.07856f
C5290 VIN.n439 VSS 0.0722f
C5291 VIN.n440 VSS 0.0722f
C5292 VIN.n441 VSS 0.0722f
C5293 VIN.n442 VSS 0.0722f
C5294 VIN.n443 VSS 0.0722f
C5295 VIN.n444 VSS 0.0722f
C5296 VIN.n445 VSS 0.0722f
C5297 VIN.n446 VSS 0.0722f
C5298 VIN.n447 VSS 0.0722f
C5299 VIN.n448 VSS 0.0722f
C5300 VIN.n449 VSS 0.0722f
C5301 VIN.n450 VSS 0.0722f
C5302 VIN.n451 VSS 0.0722f
C5303 VIN.n452 VSS 0.0722f
C5304 VIN.n453 VSS 0.0722f
C5305 VIN.n454 VSS 0.0722f
C5306 VIN.n455 VSS 0.0722f
C5307 VIN.n456 VSS 0.0722f
C5308 VIN.n457 VSS 0.0722f
C5309 VIN.n458 VSS 0.0722f
C5310 VIN.n459 VSS 0.0722f
C5311 VIN.n460 VSS 0.0722f
C5312 VIN.n461 VSS 0.0722f
C5313 VIN.n462 VSS 0.0722f
C5314 VIN.n463 VSS 0.0722f
C5315 VIN.n464 VSS 0.0722f
C5316 VIN.n465 VSS 0.0722f
C5317 VIN.n466 VSS 0.0722f
C5318 VIN.n467 VSS 0.0722f
C5319 VIN.n468 VSS 0.0722f
C5320 VIN.n469 VSS 0.06829f
C5321 VIN.n470 VSS 0.085f
C5322 VIN.n471 VSS 0.16595f
C5323 VIN.t1268 VSS 0.00879f
C5324 VIN.t972 VSS 0.00882f
C5325 VIN.t1174 VSS 0.00879f
C5326 VIN.t882 VSS 0.00882f
C5327 VIN.t834 VSS 0.00879f
C5328 VIN.t560 VSS 0.00882f
C5329 VIN.t208 VSS 0.00879f
C5330 VIN.t1980 VSS 0.00882f
C5331 VIN.t594 VSS 0.00879f
C5332 VIN.t294 VSS 0.00882f
C5333 VIN.t2026 VSS 0.00879f
C5334 VIN.t1734 VSS 0.00882f
C5335 VIN.t1938 VSS 0.00879f
C5336 VIN.t1640 VSS 0.00882f
C5337 VIN.t1998 VSS 0.00879f
C5338 VIN.t1708 VSS 0.00882f
C5339 VIN.t2098 VSS 0.00879f
C5340 VIN.t1798 VSS 0.00882f
C5341 VIN.t1756 VSS 0.00879f
C5342 VIN.t1470 VSS 0.00882f
C5343 VIN.t1176 VSS 0.00879f
C5344 VIN.t872 VSS 0.00882f
C5345 VIN.t832 VSS 0.00879f
C5346 VIN.t554 VSS 0.00882f
C5347 VIN.t1432 VSS 0.00879f
C5348 VIN.t1152 VSS 0.00882f
C5349 VIN.t824 VSS 0.00879f
C5350 VIN.t544 VSS 0.00882f
C5351 VIN.t512 VSS 0.00879f
C5352 VIN.t192 VSS 0.00882f
C5353 VIN.t1930 VSS 0.00879f
C5354 VIN.t1642 VSS 0.00882f
C5355 VIN.t242 VSS 0.00879f
C5356 VIN.t2002 VSS 0.00882f
C5357 VIN.t126 VSS 0.00879f
C5358 VIN.t1916 VSS 0.00882f
C5359 VIN.t1378 VSS 0.00879f
C5360 VIN.t1086 VSS 0.00882f
C5361 VIN.t1278 VSS 0.00879f
C5362 VIN.t994 VSS 0.00882f
C5363 VIN.t1368 VSS 0.00879f
C5364 VIN.t1072 VSS 0.00882f
C5365 VIN.t1036 VSS 0.00879f
C5366 VIN.t736 VSS 0.00882f
C5367 VIN.t942 VSS 0.00879f
C5368 VIN.t640 VSS 0.00882f
C5369 VIN.t36 VSS 0.00879f
C5370 VIN.t1838 VSS 0.00882f
C5371 VIN.t2042 VSS 0.00879f
C5372 VIN.t1738 VSS 0.00882f
C5373 VIN.t1894 VSS 0.00879f
C5374 VIN.t1598 VSS 0.00882f
C5375 VIN.t1790 VSS 0.00879f
C5376 VIN.t1492 VSS 0.00882f
C5377 VIN.t1698 VSS 0.00879f
C5378 VIN.t1414 VSS 0.00882f
C5379 VIN.t710 VSS 0.00879f
C5380 VIN.t446 VSS 0.00882f
C5381 VIN.t1322 VSS 0.00879f
C5382 VIN.t1028 VSS 0.00882f
C5383 VIN.t588 VSS 0.00879f
C5384 VIN.t292 VSS 0.00882f
C5385 VIN.t674 VSS 0.00879f
C5386 VIN.t401 VSS 0.00882f
C5387 VIN.n472 VSS 0.04791f
C5388 VIN.n473 VSS 0.0722f
C5389 VIN.n474 VSS 0.0722f
C5390 VIN.n475 VSS 0.0722f
C5391 VIN.n476 VSS 0.0722f
C5392 VIN.n477 VSS 0.0722f
C5393 VIN.n478 VSS 0.0722f
C5394 VIN.n479 VSS 0.0722f
C5395 VIN.n480 VSS 0.0722f
C5396 VIN.n481 VSS 0.0722f
C5397 VIN.n482 VSS 0.0722f
C5398 VIN.n483 VSS 0.0722f
C5399 VIN.n484 VSS 0.0722f
C5400 VIN.n485 VSS 0.0722f
C5401 VIN.n486 VSS 0.0722f
C5402 VIN.n487 VSS 0.0722f
C5403 VIN.n488 VSS 0.0722f
C5404 VIN.n489 VSS 0.0722f
C5405 VIN.n490 VSS 0.0722f
C5406 VIN.n491 VSS 0.0722f
C5407 VIN.n492 VSS 0.0722f
C5408 VIN.n493 VSS 0.0722f
C5409 VIN.n494 VSS 0.0722f
C5410 VIN.n495 VSS 0.0722f
C5411 VIN.n496 VSS 0.0722f
C5412 VIN.n497 VSS 0.0722f
C5413 VIN.n498 VSS 0.0722f
C5414 VIN.n499 VSS 0.0722f
C5415 VIN.n500 VSS 0.0722f
C5416 VIN.n501 VSS 0.0722f
C5417 VIN.n502 VSS 0.0722f
C5418 VIN.n503 VSS 0.08362f
C5419 VIN.t1512 VSS 0.00882f
C5420 VIN.t2088 VSS 0.00879f
C5421 VIN.t934 VSS 0.00882f
C5422 VIN.t1468 VSS 0.00879f
C5423 VIN.t600 VSS 0.00882f
C5424 VIN.t1162 VSS 0.00879f
C5425 VIN.t2024 VSS 0.00882f
C5426 VIN.t552 VSS 0.00879f
C5427 VIN.t584 VSS 0.00882f
C5428 VIN.t1146 VSS 0.00879f
C5429 VIN.t246 VSS 0.00882f
C5430 VIN.t822 VSS 0.00879f
C5431 VIN.t1682 VSS 0.00882f
C5432 VIN.t184 VSS 0.00879f
C5433 VIN.t1762 VSS 0.00882f
C5434 VIN.t268 VSS 0.00879f
C5435 VIN.t1848 VSS 0.00882f
C5436 VIN.t368 VSS 0.00879f
C5437 VIN.t1508 VSS 0.00882f
C5438 VIN.t2082 VSS 0.00879f
C5439 VIN.t1430 VSS 0.00882f
C5440 VIN.t1984 VSS 0.00879f
C5441 VIN.t828 VSS 0.00882f
C5442 VIN.t1390 VSS 0.00879f
C5443 VIN.t510 VSS 0.00882f
C5444 VIN.t1070 VSS 0.00879f
C5445 VIN.t586 VSS 0.00882f
C5446 VIN.t1148 VSS 0.00879f
C5447 VIN.t248 VSS 0.00882f
C5448 VIN.t816 VSS 0.00879f
C5449 VIN.t137 VSS 0.00882f
C5450 VIN.t716 VSS 0.00879f
C5451 VIN.t1582 VSS 0.00882f
C5452 VIN.t57 VSS 0.00879f
C5453 VIN.t1956 VSS 0.00882f
C5454 VIN.t492 VSS 0.00879f
C5455 VIN.t1366 VSS 0.00882f
C5456 VIN.t1908 VSS 0.00879f
C5457 VIN.t1040 VSS 0.00882f
C5458 VIN.t1574 VSS 0.00879f
C5459 VIN.t946 VSS 0.00882f
C5460 VIN.t1478 VSS 0.00879f
C5461 VIN.t786 VSS 0.00882f
C5462 VIN.t1354 VSS 0.00879f
C5463 VIN.t688 VSS 0.00882f
C5464 VIN.t1256 VSS 0.00879f
C5465 VIN.t21 VSS 0.00882f
C5466 VIN.t632 VSS 0.00879f
C5467 VIN.t1788 VSS 0.00882f
C5468 VIN.t305 VSS 0.00879f
C5469 VIN.t355 VSS 0.00882f
C5470 VIN.t920 VSS 0.00879f
C5471 VIN.t1542 VSS 0.00882f
C5472 VIN.t2110 VSS 0.00879f
C5473 VIN.t1452 VSS 0.00882f
C5474 VIN.t2014 VSS 0.00879f
C5475 VIN.t484 VSS 0.00882f
C5476 VIN.t1034 VSS 0.00879f
C5477 VIN.t1074 VSS 0.00882f
C5478 VIN.t1610 VSS 0.00879f
C5479 VIN.t206 VSS 0.00882f
C5480 VIN.t780 VSS 0.00879f
C5481 VIN.t349 VSS 0.00882f
C5482 VIN.t912 VSS 0.00879f
C5483 VIN.n504 VSS 0.07856f
C5484 VIN.n505 VSS 0.0722f
C5485 VIN.n506 VSS 0.0722f
C5486 VIN.n507 VSS 0.0722f
C5487 VIN.n508 VSS 0.0722f
C5488 VIN.n509 VSS 0.0722f
C5489 VIN.n510 VSS 0.0722f
C5490 VIN.n511 VSS 0.0722f
C5491 VIN.n512 VSS 0.0722f
C5492 VIN.n513 VSS 0.0722f
C5493 VIN.n514 VSS 0.0722f
C5494 VIN.n515 VSS 0.0722f
C5495 VIN.n516 VSS 0.0722f
C5496 VIN.n517 VSS 0.0722f
C5497 VIN.n518 VSS 0.0722f
C5498 VIN.n519 VSS 0.0722f
C5499 VIN.n520 VSS 0.0722f
C5500 VIN.n521 VSS 0.0722f
C5501 VIN.n522 VSS 0.0722f
C5502 VIN.n523 VSS 0.0722f
C5503 VIN.n524 VSS 0.0722f
C5504 VIN.n525 VSS 0.0722f
C5505 VIN.n526 VSS 0.0722f
C5506 VIN.n527 VSS 0.0722f
C5507 VIN.n528 VSS 0.0722f
C5508 VIN.n529 VSS 0.0722f
C5509 VIN.n530 VSS 0.0722f
C5510 VIN.n531 VSS 0.0722f
C5511 VIN.n532 VSS 0.0722f
C5512 VIN.n533 VSS 0.0722f
C5513 VIN.n534 VSS 0.0722f
C5514 VIN.n535 VSS 0.06829f
C5515 VIN.n536 VSS 0.06924f
C5516 VIN.n537 VSS 0.16595f
C5517 VIN.t1506 VSS 0.0088f
C5518 VIN.t1142 VSS 0.00881f
C5519 VIN.t1428 VSS 0.0088f
C5520 VIN.t1050 VSS 0.00881f
C5521 VIN.t1118 VSS 0.0088f
C5522 VIN.t714 VSS 0.00881f
C5523 VIN.t508 VSS 0.0088f
C5524 VIN.t54 VSS 0.00881f
C5525 VIN.t864 VSS 0.0088f
C5526 VIN.t482 VSS 0.00881f
C5527 VIN.t239 VSS 0.0088f
C5528 VIN.t1906 VSS 0.00881f
C5529 VIN.t121 VSS 0.0088f
C5530 VIN.t1810 VSS 0.00881f
C5531 VIN.t210 VSS 0.0088f
C5532 VIN.t1882 VSS 0.00881f
C5533 VIN.t310 VSS 0.0088f
C5534 VIN.t1968 VSS 0.00881f
C5535 VIN.t2038 VSS 0.0088f
C5536 VIN.t1638 VSS 0.00881f
C5537 VIN.t1424 VSS 0.0088f
C5538 VIN.t1052 VSS 0.00881f
C5539 VIN.t1116 VSS 0.0088f
C5540 VIN.t708 VSS 0.00881f
C5541 VIN.t1690 VSS 0.0088f
C5542 VIN.t1324 VSS 0.00881f
C5543 VIN.t1106 VSS 0.0088f
C5544 VIN.t700 VSS 0.00881f
C5545 VIN.t766 VSS 0.0088f
C5546 VIN.t388 VSS 0.00881f
C5547 VIN.t123 VSS 0.0088f
C5548 VIN.t1806 VSS 0.00881f
C5549 VIN.t536 VSS 0.0088f
C5550 VIN.t94 VSS 0.00881f
C5551 VIN.t450 VSS 0.0088f
C5552 VIN.t2080 VSS 0.00881f
C5553 VIN.t1624 VSS 0.0088f
C5554 VIN.t1250 VSS 0.00881f
C5555 VIN.t1522 VSS 0.0088f
C5556 VIN.t1156 VSS 0.00881f
C5557 VIN.t1608 VSS 0.0088f
C5558 VIN.t1238 VSS 0.00881f
C5559 VIN.t1310 VSS 0.0088f
C5560 VIN.t918 VSS 0.00881f
C5561 VIN.t1208 VSS 0.0088f
C5562 VIN.t814 VSS 0.00881f
C5563 VIN.t362 VSS 0.0088f
C5564 VIN.t2008 VSS 0.00881f
C5565 VIN.t254 VSS 0.0088f
C5566 VIN.t1922 VSS 0.00881f
C5567 VIN.t74 VSS 0.0088f
C5568 VIN.t1766 VSS 0.00881f
C5569 VIN.t2064 VSS 0.0088f
C5570 VIN.t1672 VSS 0.00881f
C5571 VIN.t1970 VSS 0.0088f
C5572 VIN.t1572 VSS 0.00881f
C5573 VIN.t990 VSS 0.0088f
C5574 VIN.t592 VSS 0.00881f
C5575 VIN.t1560 VSS 0.0088f
C5576 VIN.t1196 VSS 0.00881f
C5577 VIN.t858 VSS 0.0088f
C5578 VIN.t474 VSS 0.00881f
C5579 VIN.t954 VSS 0.0088f
C5580 VIN.t564 VSS 0.00881f
C5581 VIN.n538 VSS 0.04791f
C5582 VIN.n539 VSS 0.0722f
C5583 VIN.n540 VSS 0.0722f
C5584 VIN.n541 VSS 0.0722f
C5585 VIN.n542 VSS 0.0722f
C5586 VIN.n543 VSS 0.0722f
C5587 VIN.n544 VSS 0.0722f
C5588 VIN.n545 VSS 0.0722f
C5589 VIN.n546 VSS 0.0722f
C5590 VIN.n547 VSS 0.0722f
C5591 VIN.n548 VSS 0.0722f
C5592 VIN.n549 VSS 0.0722f
C5593 VIN.n550 VSS 0.0722f
C5594 VIN.n551 VSS 0.0722f
C5595 VIN.n552 VSS 0.0722f
C5596 VIN.n553 VSS 0.0722f
C5597 VIN.n554 VSS 0.0722f
C5598 VIN.n555 VSS 0.0722f
C5599 VIN.n556 VSS 0.0722f
C5600 VIN.n557 VSS 0.0722f
C5601 VIN.n558 VSS 0.0722f
C5602 VIN.n559 VSS 0.0722f
C5603 VIN.n560 VSS 0.0722f
C5604 VIN.n561 VSS 0.0722f
C5605 VIN.n562 VSS 0.0722f
C5606 VIN.n563 VSS 0.0722f
C5607 VIN.n564 VSS 0.0722f
C5608 VIN.n565 VSS 0.0722f
C5609 VIN.n566 VSS 0.0722f
C5610 VIN.n567 VSS 0.0722f
C5611 VIN.n568 VSS 0.0722f
C5612 VIN.n569 VSS 0.08362f
C5613 VIN.n570 VSS 0.085f
C5614 VIN.n571 VSS 0.16595f
C5615 VIN.t794 VSS 0.00882f
C5616 VIN.t171 VSS 0.00882f
C5617 VIN.t1904 VSS 0.00882f
C5618 VIN.t1316 VSS 0.00882f
C5619 VIN.t1896 VSS 0.00882f
C5620 VIN.t1556 VSS 0.00882f
C5621 VIN.t970 VSS 0.00882f
C5622 VIN.t1048 VSS 0.00882f
C5623 VIN.t1128 VSS 0.00882f
C5624 VIN.t796 VSS 0.00882f
C5625 VIN.t702 VSS 0.00882f
C5626 VIN.t33 VSS 0.00882f
C5627 VIN.t1808 VSS 0.00882f
C5628 VIN.t1892 VSS 0.00882f
C5629 VIN.t1550 VSS 0.00882f
C5630 VIN.t1466 VSS 0.00882f
C5631 VIN.t866 VSS 0.00882f
C5632 VIN.t1236 VSS 0.00882f
C5633 VIN.t624 VSS 0.00882f
C5634 VIN.t290 VSS 0.00882f
C5635 VIN.t182 VSS 0.00882f
C5636 VIN.t2104 VSS 0.00882f
C5637 VIN.t1996 VSS 0.00882f
C5638 VIN.t1396 VSS 0.00882f
C5639 VIN.t1080 VSS 0.00882f
C5640 VIN.t1656 VSS 0.00882f
C5641 VIN.t830 VSS 0.00882f
C5642 VIN.t734 VSS 0.00882f
C5643 VIN.t1772 VSS 0.00882f
C5644 VIN.t343 VSS 0.00882f
C5645 VIN.t1520 VSS 0.00882f
C5646 VIN.t1652 VSS 0.00882f
C5647 VIN.t518 VSS 0.00879f
C5648 VIN.n572 VSS 0.0755f
C5649 VIN.t399 VSS 0.00879f
C5650 VIN.n573 VSS 0.06914f
C5651 VIN.t1240 VSS 0.00879f
C5652 VIN.n574 VSS 0.06914f
C5653 VIN.t630 VSS 0.00879f
C5654 VIN.n575 VSS 0.06914f
C5655 VIN.t1622 VSS 0.00879f
C5656 VIN.n576 VSS 0.06914f
C5657 VIN.t1714 VSS 0.00879f
C5658 VIN.n577 VSS 0.06914f
C5659 VIN.t534 VSS 0.00879f
C5660 VIN.n578 VSS 0.06914f
C5661 VIN.t1962 VSS 0.00879f
C5662 VIN.n579 VSS 0.06914f
C5663 VIN.t237 VSS 0.00879f
C5664 VIN.n580 VSS 0.06914f
C5665 VIN.t860 VSS 0.00879f
C5666 VIN.n581 VSS 0.06914f
C5667 VIN.t958 VSS 0.00879f
C5668 VIN.n582 VSS 0.06914f
C5669 VIN.t1114 VSS 0.00879f
C5670 VIN.n583 VSS 0.06914f
C5671 VIN.t1202 VSS 0.00879f
C5672 VIN.n584 VSS 0.06914f
C5673 VIN.t1502 VSS 0.00879f
C5674 VIN.n585 VSS 0.06914f
C5675 VIN.t18 VSS 0.00879f
C5676 VIN.n586 VSS 0.06914f
C5677 VIN.t1750 VSS 0.00879f
C5678 VIN.n587 VSS 0.06914f
C5679 VIN.t330 VSS 0.00879f
C5680 VIN.n588 VSS 0.06914f
C5681 VIN.t444 VSS 0.00879f
C5682 VIN.n589 VSS 0.06914f
C5683 VIN.t744 VSS 0.00879f
C5684 VIN.n590 VSS 0.06914f
C5685 VIN.t664 VSS 0.00879f
C5686 VIN.n591 VSS 0.06914f
C5687 VIN.t1004 VSS 0.00879f
C5688 VIN.n592 VSS 0.06914f
C5689 VIN.t1580 VSS 0.00879f
C5690 VIN.n593 VSS 0.06914f
C5691 VIN.t1680 VSS 0.00879f
C5692 VIN.n594 VSS 0.06914f
C5693 VIN.t2012 VSS 0.00879f
C5694 VIN.n595 VSS 0.06914f
C5695 VIN.t1936 VSS 0.00879f
C5696 VIN.n596 VSS 0.06914f
C5697 VIN.t1858 VSS 0.00879f
C5698 VIN.n597 VSS 0.06914f
C5699 VIN.t442 VSS 0.00879f
C5700 VIN.n598 VSS 0.06914f
C5701 VIN.t748 VSS 0.00879f
C5702 VIN.n599 VSS 0.06914f
C5703 VIN.t118 VSS 0.00879f
C5704 VIN.n600 VSS 0.06914f
C5705 VIN.t764 VSS 0.00879f
C5706 VIN.n601 VSS 0.06914f
C5707 VIN.t1100 VSS 0.00879f
C5708 VIN.n602 VSS 0.06914f
C5709 VIN.t1688 VSS 0.00879f
C5710 VIN.n603 VSS 0.06524f
C5711 VIN.t215 VSS 0.00881f
C5712 VIN.t792 VSS 0.0088f
C5713 VIN.t105 VSS 0.00881f
C5714 VIN.t696 VSS 0.0088f
C5715 VIN.t1854 VSS 0.00881f
C5716 VIN.t386 VSS 0.0088f
C5717 VIN.t1266 VSS 0.00881f
C5718 VIN.t1804 VSS 0.0088f
C5719 VIN.t1606 VSS 0.00881f
C5720 VIN.t91 VSS 0.0088f
C5721 VIN.t1022 VSS 0.00881f
C5722 VIN.t1548 VSS 0.0088f
C5723 VIN.t932 VSS 0.00881f
C5724 VIN.t1462 VSS 0.0088f
C5725 VIN.t1002 VSS 0.00881f
C5726 VIN.t1530 VSS 0.0088f
C5727 VIN.t1078 VSS 0.00881f
C5728 VIN.t1620 VSS 0.0088f
C5729 VIN.t746 VSS 0.00881f
C5730 VIN.t1320 VSS 0.0088f
C5731 VIN.t103 VSS 0.00881f
C5732 VIN.t698 VSS 0.0088f
C5733 VIN.t1856 VSS 0.00881f
C5734 VIN.t382 VSS 0.0088f
C5735 VIN.t428 VSS 0.00881f
C5736 VIN.t978 VSS 0.0088f
C5737 VIN.t1836 VSS 0.00881f
C5738 VIN.t359 VSS 0.0088f
C5739 VIN.t1500 VSS 0.00881f
C5740 VIN.t2078 VSS 0.0088f
C5741 VIN.t926 VSS 0.00881f
C5742 VIN.t1456 VSS 0.0088f
C5743 VIN.t1292 VSS 0.00881f
C5744 VIN.t1828 VSS 0.0088f
C5745 VIN.t1194 VSS 0.00881f
C5746 VIN.t1732 VSS 0.0088f
C5747 VIN.t347 VSS 0.00881f
C5748 VIN.t910 VSS 0.0088f
C5749 VIN.t235 VSS 0.00881f
C5750 VIN.t810 VSS 0.0088f
C5751 VIN.t341 VSS 0.00881f
C5752 VIN.t900 VSS 0.0088f
C5753 VIN.t2056 VSS 0.00881f
C5754 VIN.t572 VSS 0.0088f
C5755 VIN.t1952 VSS 0.00881f
C5756 VIN.t480 VSS 0.0088f
C5757 VIN.t1130 VSS 0.00881f
C5758 VIN.t1660 VSS 0.0088f
C5759 VIN.t1032 VSS 0.00881f
C5760 VIN.t1564 VSS 0.0088f
C5761 VIN.t884 VSS 0.00881f
C5762 VIN.t1434 VSS 0.0088f
C5763 VIN.t782 VSS 0.00881f
C5764 VIN.t1352 VSS 0.0088f
C5765 VIN.t680 VSS 0.00881f
C5766 VIN.t1254 VSS 0.0088f
C5767 VIN.t1728 VSS 0.00881f
C5768 VIN.t232 VSS 0.0088f
C5769 VIN.t280 VSS 0.00881f
C5770 VIN.t844 VSS 0.0088f
C5771 VIN.t1602 VSS 0.00881f
C5772 VIN.t81 VSS 0.0088f
C5773 VIN.t1702 VSS 0.00881f
C5774 VIN.t200 VSS 0.0088f
C5775 VIN.n604 VSS 0.04791f
C5776 VIN.n605 VSS 0.0722f
C5777 VIN.n606 VSS 0.0722f
C5778 VIN.n607 VSS 0.0722f
C5779 VIN.n608 VSS 0.0722f
C5780 VIN.n609 VSS 0.0722f
C5781 VIN.n610 VSS 0.0722f
C5782 VIN.n611 VSS 0.0722f
C5783 VIN.n612 VSS 0.0722f
C5784 VIN.n613 VSS 0.0722f
C5785 VIN.n614 VSS 0.0722f
C5786 VIN.n615 VSS 0.0722f
C5787 VIN.n616 VSS 0.0722f
C5788 VIN.n617 VSS 0.0722f
C5789 VIN.n618 VSS 0.0722f
C5790 VIN.n619 VSS 0.0722f
C5791 VIN.n620 VSS 0.0722f
C5792 VIN.n621 VSS 0.0722f
C5793 VIN.n622 VSS 0.0722f
C5794 VIN.n623 VSS 0.0722f
C5795 VIN.n624 VSS 0.0722f
C5796 VIN.n625 VSS 0.0722f
C5797 VIN.n626 VSS 0.0722f
C5798 VIN.n627 VSS 0.0722f
C5799 VIN.n628 VSS 0.0722f
C5800 VIN.n629 VSS 0.0722f
C5801 VIN.n630 VSS 0.0722f
C5802 VIN.n631 VSS 0.0722f
C5803 VIN.n632 VSS 0.0722f
C5804 VIN.n633 VSS 0.0722f
C5805 VIN.n634 VSS 0.0722f
C5806 VIN.n635 VSS 0.08362f
C5807 VIN.n636 VSS 0.08457f
C5808 VIN.n637 VSS 0.08298f
C5809 VIN.n638 VSS 0.16191f
C5810 VIN.n639 VSS 0.08298f
C5811 VIN.n640 VSS 0.05464f
C5812 VIN.t1362 VSS 0.00879f
C5813 VIN.t968 VSS 0.00882f
C5814 VIN.t742 VSS 0.00879f
C5815 VIN.t357 VSS 0.00882f
C5816 VIN.t440 VSS 0.00879f
C5817 VIN.t2068 VSS 0.00882f
C5818 VIN.t1852 VSS 0.00879f
C5819 VIN.t1454 VSS 0.00882f
C5820 VIN.t425 VSS 0.00879f
C5821 VIN.t2060 VSS 0.00882f
C5822 VIN.t12 VSS 0.00879f
C5823 VIN.t1730 VSS 0.00882f
C5824 VIN.t1498 VSS 0.00879f
C5825 VIN.t1140 VSS 0.00882f
C5826 VIN.t1578 VSS 0.00879f
C5827 VIN.t1222 VSS 0.00882f
C5828 VIN.t1670 VSS 0.00879f
C5829 VIN.t1306 VSS 0.00882f
C5830 VIN.t1364 VSS 0.00879f
C5831 VIN.t964 VSS 0.00882f
C5832 VIN.t1270 VSS 0.00879f
C5833 VIN.t870 VSS 0.00882f
C5834 VIN.t656 VSS 0.00879f
C5835 VIN.t250 VSS 0.00882f
C5836 VIN.t323 VSS 0.00879f
C5837 VIN.t1978 VSS 0.00882f
C5838 VIN.t417 VSS 0.00879f
C5839 VIN.t2062 VSS 0.00882f
C5840 VIN.t15 VSS 0.00879f
C5841 VIN.t1726 VSS 0.00882f
C5842 VIN.t2030 VSS 0.00879f
C5843 VIN.t1628 VSS 0.00882f
C5844 VIN.t1420 VSS 0.00879f
C5845 VIN.t1044 VSS 0.00882f
C5846 VIN.t1776 VSS 0.00879f
C5847 VIN.t1400 VSS 0.00882f
C5848 VIN.t1190 VSS 0.00879f
C5849 VIN.t788 VSS 0.00882f
C5850 VIN.t856 VSS 0.00879f
C5851 VIN.t478 VSS 0.00882f
C5852 VIN.t758 VSS 0.00879f
C5853 VIN.t380 VSS 0.00882f
C5854 VIN.t620 VSS 0.00879f
C5855 VIN.t204 VSS 0.00882f
C5856 VIN.t528 VSS 0.00879f
C5857 VIN.t86 VSS 0.00882f
C5858 VIN.t1944 VSS 0.00879f
C5859 VIN.t1544 VSS 0.00882f
C5860 VIN.t1612 VSS 0.00879f
C5861 VIN.t1242 VSS 0.00882f
C5862 VIN.t166 VSS 0.00879f
C5863 VIN.t1826 VSS 0.00882f
C5864 VIN.t1394 VSS 0.00879f
C5865 VIN.t1008 VSS 0.00882f
C5866 VIN.t1308 VSS 0.00879f
C5867 VIN.t908 VSS 0.00882f
C5868 VIN.t284 VSS 0.00879f
C5869 VIN.t1942 VSS 0.00882f
C5870 VIN.t906 VSS 0.00879f
C5871 VIN.t516 VSS 0.00882f
C5872 VIN.t2102 VSS 0.00879f
C5873 VIN.t1696 VSS 0.00882f
C5874 VIN.t152 VSS 0.00879f
C5875 VIN.t1820 VSS 0.00882f
C5876 VIN.n641 VSS 0.07856f
C5877 VIN.n642 VSS 0.0722f
C5878 VIN.n643 VSS 0.0722f
C5879 VIN.n644 VSS 0.0722f
C5880 VIN.n645 VSS 0.0722f
C5881 VIN.n646 VSS 0.0722f
C5882 VIN.n647 VSS 0.0722f
C5883 VIN.n648 VSS 0.0722f
C5884 VIN.n649 VSS 0.0722f
C5885 VIN.n650 VSS 0.0722f
C5886 VIN.n651 VSS 0.0722f
C5887 VIN.n652 VSS 0.0722f
C5888 VIN.n653 VSS 0.0722f
C5889 VIN.n654 VSS 0.0722f
C5890 VIN.n655 VSS 0.0722f
C5891 VIN.n656 VSS 0.0722f
C5892 VIN.n657 VSS 0.0722f
C5893 VIN.n658 VSS 0.0722f
C5894 VIN.n659 VSS 0.0722f
C5895 VIN.n660 VSS 0.0722f
C5896 VIN.n661 VSS 0.0722f
C5897 VIN.n662 VSS 0.0722f
C5898 VIN.n663 VSS 0.0722f
C5899 VIN.n664 VSS 0.0722f
C5900 VIN.n665 VSS 0.0722f
C5901 VIN.n666 VSS 0.0722f
C5902 VIN.n667 VSS 0.0722f
C5903 VIN.n668 VSS 0.0722f
C5904 VIN.n669 VSS 0.0722f
C5905 VIN.n670 VSS 0.0722f
C5906 VIN.n671 VSS 0.0722f
C5907 VIN.n672 VSS 0.06829f
C5908 VIN.n673 VSS 0.06924f
C5909 VIN.n674 VSS 0.08298f
C5910 VIN.n675 VSS 0.16191f
C5911 VIN.n676 VSS 0.08298f
C5912 VIN.n677 VSS 0.08197f
C5913 VIN.t415 VSS 0.00882f
C5914 VIN.t1974 VSS 0.00879f
C5915 VIN.t303 VSS 0.00882f
C5916 VIN.t762 VSS 0.00879f
C5917 VIN.t2020 VSS 0.00882f
C5918 VIN.t227 VSS 0.00879f
C5919 VIN.t1418 VSS 0.00882f
C5920 VIN.t1588 VSS 0.00879f
C5921 VIN.t1774 VSS 0.00882f
C5922 VIN.t570 VSS 0.00879f
C5923 VIN.t1186 VSS 0.00882f
C5924 VIN.t1928 VSS 0.00879f
C5925 VIN.t1094 VSS 0.00882f
C5926 VIN.t712 VSS 0.00879f
C5927 VIN.t1172 VSS 0.00882f
C5928 VIN.t1844 VSS 0.00879f
C5929 VIN.t1248 VSS 0.00882f
C5930 VIN.t658 VSS 0.00879f
C5931 VIN.t930 VSS 0.00882f
C5932 VIN.t100 VSS 0.00879f
C5933 VIN.t298 VSS 0.00882f
C5934 VIN.t1482 VSS 0.00879f
C5935 VIN.t2022 VSS 0.00882f
C5936 VIN.t984 VSS 0.00879f
C5937 VIN.t580 VSS 0.00882f
C5938 VIN.t1304 VSS 0.00879f
C5939 VIN.t2006 VSS 0.00882f
C5940 VIN.t616 VSS 0.00879f
C5941 VIN.t1676 VSS 0.00882f
C5942 VIN.t24 VSS 0.00879f
C5943 VIN.t1096 VSS 0.00882f
C5944 VIN.t1444 VSS 0.00879f
C5945 VIN.t1446 VSS 0.00882f
C5946 VIN.t434 VSS 0.00879f
C5947 VIN.t1360 VSS 0.00882f
C5948 VIN.t1252 VSS 0.00879f
C5949 VIN.t524 VSS 0.00882f
C5950 VIN.t1264 VSS 0.00879f
C5951 VIN.t438 VSS 0.00882f
C5952 VIN.t2086 VSS 0.00879f
C5953 VIN.t514 VSS 0.00882f
C5954 VIN.t896 VSS 0.00879f
C5955 VIN.t160 VSS 0.00882f
C5956 VIN.t376 VSS 0.00879f
C5957 VIN.t9 VSS 0.00882f
C5958 VIN.t1206 VSS 0.00879f
C5959 VIN.t1298 VSS 0.00882f
C5960 VIN.t1220 VSS 0.00879f
C5961 VIN.t1198 VSS 0.00882f
C5962 VIN.t2036 VSS 0.00879f
C5963 VIN.t1060 VSS 0.00882f
C5964 VIN.t1516 VSS 0.00879f
C5965 VIN.t952 VSS 0.00882f
C5966 VIN.t319 VSS 0.00879f
C5967 VIN.t854 VSS 0.00882f
C5968 VIN.t1160 VSS 0.00879f
C5969 VIN.t1902 VSS 0.00882f
C5970 VIN.t413 VSS 0.00879f
C5971 VIN.t472 VSS 0.00882f
C5972 VIN.t728 VSS 0.00879f
C5973 VIN.t1768 VSS 0.00882f
C5974 VIN.t1524 VSS 0.00879f
C5975 VIN.t1868 VSS 0.00882f
C5976 VIN.t706 VSS 0.00879f
C5977 VIN.n678 VSS 0.04791f
C5978 VIN.n679 VSS 0.0722f
C5979 VIN.n680 VSS 0.0722f
C5980 VIN.n681 VSS 0.0722f
C5981 VIN.n682 VSS 0.0722f
C5982 VIN.n683 VSS 0.0722f
C5983 VIN.n684 VSS 0.0722f
C5984 VIN.n685 VSS 0.0722f
C5985 VIN.n686 VSS 0.0722f
C5986 VIN.n687 VSS 0.0722f
C5987 VIN.n688 VSS 0.0722f
C5988 VIN.n689 VSS 0.0722f
C5989 VIN.n690 VSS 0.0722f
C5990 VIN.n691 VSS 0.0722f
C5991 VIN.n692 VSS 0.0722f
C5992 VIN.n693 VSS 0.0722f
C5993 VIN.n694 VSS 0.0722f
C5994 VIN.n695 VSS 0.0722f
C5995 VIN.n696 VSS 0.0722f
C5996 VIN.n697 VSS 0.0722f
C5997 VIN.n698 VSS 0.0722f
C5998 VIN.n699 VSS 0.0722f
C5999 VIN.n700 VSS 0.0722f
C6000 VIN.n701 VSS 0.0722f
C6001 VIN.n702 VSS 0.0722f
C6002 VIN.n703 VSS 0.0722f
C6003 VIN.n704 VSS 0.0722f
C6004 VIN.n705 VSS 0.0722f
C6005 VIN.n706 VSS 0.0722f
C6006 VIN.n707 VSS 0.0722f
C6007 VIN.n708 VSS 0.0722f
C6008 VIN.n709 VSS 0.08362f
C6009 VIN.n710 VSS 0.07893f
C6010 VIN.n711 VSS 0.08298f
C6011 VIN.n712 VSS 0.16191f
C6012 VIN.n713 VSS 0.08298f
C6013 VIN.t2052 VSS 0.0088f
C6014 VIN.t1182 VSS 0.00881f
C6015 VIN.t1382 VSS 0.0088f
C6016 VIN.t504 VSS 0.00881f
C6017 VIN.t852 VSS 0.0088f
C6018 VIN.t2000 VSS 0.00881f
C6019 VIN.t146 VSS 0.0088f
C6020 VIN.t1346 VSS 0.00881f
C6021 VIN.t498 VSS 0.0088f
C6022 VIN.t1636 VSS 0.00881f
C6023 VIN.t1990 VSS 0.0088f
C6024 VIN.t1136 VSS 0.00881f
C6025 VIN.t1336 VSS 0.0088f
C6026 VIN.t462 VSS 0.00881f
C6027 VIN.t432 VSS 0.0088f
C6028 VIN.t1562 VSS 0.00881f
C6029 VIN.t1272 VSS 0.0088f
C6030 VIN.t392 VSS 0.00881f
C6031 VIN.t738 VSS 0.0088f
C6032 VIN.t1900 VSS 0.00881f
C6033 VIN.t1554 VSS 0.0088f
C6034 VIN.t686 VSS 0.00881f
C6035 VIN.t894 VSS 0.0088f
C6036 VIN.t2048 VSS 0.00881f
C6037 VIN.t374 VSS 0.0088f
C6038 VIN.t1514 VSS 0.00881f
C6039 VIN.t1226 VSS 0.0088f
C6040 VIN.t338 VSS 0.00881f
C6041 VIN.t690 VSS 0.0088f
C6042 VIN.t1850 VSS 0.00881f
C6043 VIN.t1504 VSS 0.0088f
C6044 VIN.t638 VSS 0.00881f
C6045 VIN.t840 VSS 0.0088f
C6046 VIN.t1988 VSS 0.00881f
C6047 VIN.t1846 VSS 0.0088f
C6048 VIN.t976 VSS 0.00881f
C6049 VIN.t1180 VSS 0.0088f
C6050 VIN.t277 VSS 0.00881f
C6051 VIN.t646 VSS 0.0088f
C6052 VIN.t1802 VSS 0.00881f
C6053 VIN.t1464 VSS 0.0088f
C6054 VIN.t598 VSS 0.00881f
C6055 VIN.t986 VSS 0.0088f
C6056 VIN.t30 VSS 0.00881f
C6057 VIN.t1796 VSS 0.0088f
C6058 VIN.t936 VSS 0.00881f
C6059 VIN.t1122 VSS 0.0088f
C6060 VIN.t213 VSS 0.00881f
C6061 VIN.t608 VSS 0.0088f
C6062 VIN.t1754 VSS 0.00881f
C6063 VIN.t924 VSS 0.0088f
C6064 VIN.t2076 VSS 0.00881f
C6065 VIN.t938 VSS 0.0088f
C6066 VIN.t2094 VSS 0.00881f
C6067 VIN.t1746 VSS 0.0088f
C6068 VIN.t880 VSS 0.00881f
C6069 VIN.t1026 VSS 0.0088f
C6070 VIN.t97 VSS 0.00881f
C6071 VIN.t1350 VSS 0.0088f
C6072 VIN.t470 VSS 0.00881f
C6073 VIN.t808 VSS 0.0088f
C6074 VIN.t1966 VSS 0.00881f
C6075 VIN.t51 VSS 0.0088f
C6076 VIN.t1276 VSS 0.00881f
C6077 VIN.n714 VSS 0.07856f
C6078 VIN.n715 VSS 0.0722f
C6079 VIN.n716 VSS 0.0722f
C6080 VIN.n717 VSS 0.0722f
C6081 VIN.n718 VSS 0.0722f
C6082 VIN.n719 VSS 0.0722f
C6083 VIN.n720 VSS 0.0722f
C6084 VIN.n721 VSS 0.0722f
C6085 VIN.n722 VSS 0.0722f
C6086 VIN.n723 VSS 0.0722f
C6087 VIN.n724 VSS 0.0722f
C6088 VIN.n725 VSS 0.0722f
C6089 VIN.n726 VSS 0.0722f
C6090 VIN.n727 VSS 0.0722f
C6091 VIN.n728 VSS 0.0722f
C6092 VIN.n729 VSS 0.0722f
C6093 VIN.n730 VSS 0.0722f
C6094 VIN.n731 VSS 0.0722f
C6095 VIN.n732 VSS 0.0722f
C6096 VIN.n733 VSS 0.0722f
C6097 VIN.n734 VSS 0.0722f
C6098 VIN.n735 VSS 0.0722f
C6099 VIN.n736 VSS 0.0722f
C6100 VIN.n737 VSS 0.0722f
C6101 VIN.n738 VSS 0.0722f
C6102 VIN.n739 VSS 0.0722f
C6103 VIN.n740 VSS 0.0722f
C6104 VIN.n741 VSS 0.0722f
C6105 VIN.n742 VSS 0.0722f
C6106 VIN.n743 VSS 0.0722f
C6107 VIN.n744 VSS 0.0722f
C6108 VIN.n745 VSS 0.06829f
C6109 VIN.n746 VSS 0.06924f
C6110 VIN.n747 VSS 0.05161f
C6111 VIN.n748 VSS 0.08298f
C6112 VIN.n749 VSS 0.16191f
C6113 VIN.n750 VSS 0.08298f
C6114 VIN.t45 VSS 0.00882f
C6115 VIN.t940 VSS 0.00882f
C6116 VIN.t411 VSS 0.00882f
C6117 VIN.t1760 VSS 0.00882f
C6118 VIN.t732 VSS 0.00882f
C6119 VIN.t2100 VSS 0.00882f
C6120 VIN.t886 VSS 0.00882f
C6121 VIN.t2010 VSS 0.00882f
C6122 VIN.t826 VSS 0.00882f
C6123 VIN.t288 VSS 0.00882f
C6124 VIN.t1650 VSS 0.00882f
C6125 VIN.t1150 VSS 0.00882f
C6126 VIN.t1450 VSS 0.00882f
C6127 VIN.t778 VSS 0.00882f
C6128 VIN.t244 VSS 0.00882f
C6129 VIN.t1600 VSS 0.00882f
C6130 VIN.t578 VSS 0.00882f
C6131 VIN.t1408 VSS 0.00882f
C6132 VIN.t1416 VSS 0.00882f
C6133 VIN.t189 VSS 0.00882f
C6134 VIN.t1068 VSS 0.00882f
C6135 VIN.t538 VSS 0.00882f
C6136 VIN.t1376 VSS 0.00882f
C6137 VIN.t1386 VSS 0.00882f
C6138 VIN.t134 VSS 0.00882f
C6139 VIN.t1686 VSS 0.00882f
C6140 VIN.t496 VSS 0.00882f
C6141 VIN.t1328 VSS 0.00882f
C6142 VIN.t576 VSS 0.00882f
C6143 VIN.t904 VSS 0.00882f
C6144 VIN.t1694 VSS 0.00882f
C6145 VIN.t878 VSS 0.00882f
C6146 VIN.t1864 VSS 0.00879f
C6147 VIN.n751 VSS 0.04485f
C6148 VIN.t660 VSS 0.00879f
C6149 VIN.n752 VSS 0.06914f
C6150 VIN.t1886 VSS 0.00879f
C6151 VIN.n753 VSS 0.06914f
C6152 VIN.t1552 VSS 0.00879f
C6153 VIN.n754 VSS 0.06914f
C6154 VIN.t258 VSS 0.00879f
C6155 VIN.n755 VSS 0.06914f
C6156 VIN.t1474 VSS 0.00879f
C6157 VIN.n756 VSS 0.06914f
C6158 VIN.t654 VSS 0.00879f
C6159 VIN.n757 VSS 0.06914f
C6160 VIN.t1170 VSS 0.00879f
C6161 VIN.n758 VSS 0.06914f
C6162 VIN.t328 VSS 0.00879f
C6163 VIN.n759 VSS 0.06914f
C6164 VIN.t308 VSS 0.00879f
C6165 VIN.n760 VSS 0.06914f
C6166 VIN.t1510 VSS 0.00879f
C6167 VIN.n761 VSS 0.06914f
C6168 VIN.t2050 VSS 0.00879f
C6169 VIN.n762 VSS 0.06914f
C6170 VIN.t1214 VSS 0.00879f
C6171 VIN.n763 VSS 0.06914f
C6172 VIN.t378 VSS 0.00879f
C6173 VIN.n764 VSS 0.06914f
C6174 VIN.t366 VSS 0.00879f
C6175 VIN.n765 VSS 0.06914f
C6176 VIN.t1558 VSS 0.00879f
C6177 VIN.n766 VSS 0.06914f
C6178 VIN.t568 VSS 0.00879f
C6179 VIN.n767 VSS 0.06914f
C6180 VIN.t1260 VSS 0.00879f
C6181 VIN.n768 VSS 0.06914f
C6182 VIN.t1764 VSS 0.00879f
C6183 VIN.n769 VSS 0.06914f
C6184 VIN.t423 VSS 0.00879f
C6185 VIN.n770 VSS 0.06914f
C6186 VIN.t39 VSS 0.00879f
C6187 VIN.n771 VSS 0.06914f
C6188 VIN.t618 VSS 0.00879f
C6189 VIN.n772 VSS 0.06914f
C6190 VIN.t1314 VSS 0.00879f
C6191 VIN.n773 VSS 0.06914f
C6192 VIN.t1818 VSS 0.00879f
C6193 VIN.n774 VSS 0.06914f
C6194 VIN.t982 VSS 0.00879f
C6195 VIN.n775 VSS 0.06914f
C6196 VIN.t1870 VSS 0.00879f
C6197 VIN.n776 VSS 0.06914f
C6198 VIN.t1064 VSS 0.00879f
C6199 VIN.n777 VSS 0.06914f
C6200 VIN.t1722 VSS 0.00879f
C6201 VIN.n778 VSS 0.06914f
C6202 VIN.t726 VSS 0.00879f
C6203 VIN.n779 VSS 0.06914f
C6204 VIN.t1402 VSS 0.00879f
C6205 VIN.n780 VSS 0.06914f
C6206 VIN.t1926 VSS 0.00879f
C6207 VIN.n781 VSS 0.06914f
C6208 VIN.t1112 VSS 0.00879f
C6209 VIN.n782 VSS 0.08056f
C6210 VIN.n783 VSS 0.08457f
C6211 VIN.t157 VSS 0.00881f
C6212 VIN.t1340 VSS 0.0088f
C6213 VIN.t1518 VSS 0.00881f
C6214 VIN.t634 VSS 0.0088f
C6215 VIN.t1024 VSS 0.00881f
C6216 VIN.t71 VSS 0.0088f
C6217 VIN.t334 VSS 0.00881f
C6218 VIN.t1472 VSS 0.0088f
C6219 VIN.t652 VSS 0.00881f
C6220 VIN.t1782 VSS 0.0088f
C6221 VIN.t84 VSS 0.00881f
C6222 VIN.t1286 VSS 0.0088f
C6223 VIN.t1476 VSS 0.00881f
C6224 VIN.t596 VSS 0.0088f
C6225 VIN.t582 VSS 0.00881f
C6226 VIN.t1718 VSS 0.0088f
C6227 VIN.t1426 VSS 0.00881f
C6228 VIN.t540 VSS 0.0088f
C6229 VIN.t916 VSS 0.00881f
C6230 VIN.t2054 VSS 0.0088f
C6231 VIN.t1724 VSS 0.00881f
C6232 VIN.t838 VSS 0.0088f
C6233 VIN.t1066 VSS 0.00881f
C6234 VIN.t132 VSS 0.0088f
C6235 VIN.t542 VSS 0.00881f
C6236 VIN.t1666 VSS 0.0088f
C6237 VIN.t1392 VSS 0.00881f
C6238 VIN.t500 VSS 0.0088f
C6239 VIN.t862 VSS 0.00881f
C6240 VIN.t1992 VSS 0.0088f
C6241 VIN.t1678 VSS 0.00881f
C6242 VIN.t790 VSS 0.0088f
C6243 VIN.t1016 VSS 0.00881f
C6244 VIN.t60 VSS 0.0088f
C6245 VIN.t2004 VSS 0.00881f
C6246 VIN.t1124 VSS 0.0088f
C6247 VIN.t1348 VSS 0.00881f
C6248 VIN.t454 VSS 0.0088f
C6249 VIN.t820 VSS 0.00881f
C6250 VIN.t1948 VSS 0.0088f
C6251 VIN.t1634 VSS 0.00881f
C6252 VIN.t740 VSS 0.0088f
C6253 VIN.t1144 VSS 0.00881f
C6254 VIN.t217 VSS 0.0088f
C6255 VIN.t1960 VSS 0.00881f
C6256 VIN.t1076 VSS 0.0088f
C6257 VIN.t1296 VSS 0.00881f
C6258 VIN.t397 VSS 0.0088f
C6259 VIN.t770 VSS 0.00881f
C6260 VIN.t1910 VSS 0.0088f
C6261 VIN.t1092 VSS 0.00881f
C6262 VIN.t169 VSS 0.0088f
C6263 VIN.t1104 VSS 0.00881f
C6264 VIN.t173 VSS 0.0088f
C6265 VIN.t1920 VSS 0.00881f
C6266 VIN.t1030 VSS 0.0088f
C6267 VIN.t1188 VSS 0.00881f
C6268 VIN.t273 VSS 0.0088f
C6269 VIN.t1486 VSS 0.00881f
C6270 VIN.t612 VSS 0.0088f
C6271 VIN.t980 VSS 0.00881f
C6272 VIN.t3 VSS 0.0088f
C6273 VIN.t256 VSS 0.00881f
C6274 VIN.t1412 VSS 0.0088f
C6275 VIN.n784 VSS 0.07856f
C6276 VIN.n785 VSS 0.0722f
C6277 VIN.n786 VSS 0.0722f
C6278 VIN.n787 VSS 0.0722f
C6279 VIN.n788 VSS 0.0722f
C6280 VIN.n789 VSS 0.0722f
C6281 VIN.n790 VSS 0.0722f
C6282 VIN.n791 VSS 0.0722f
C6283 VIN.n792 VSS 0.0722f
C6284 VIN.n793 VSS 0.0722f
C6285 VIN.n794 VSS 0.0722f
C6286 VIN.n795 VSS 0.0722f
C6287 VIN.n796 VSS 0.0722f
C6288 VIN.n797 VSS 0.0722f
C6289 VIN.n798 VSS 0.0722f
C6290 VIN.n799 VSS 0.0722f
C6291 VIN.n800 VSS 0.0722f
C6292 VIN.n801 VSS 0.0722f
C6293 VIN.n802 VSS 0.0722f
C6294 VIN.n803 VSS 0.0722f
C6295 VIN.n804 VSS 0.0722f
C6296 VIN.n805 VSS 0.0722f
C6297 VIN.n806 VSS 0.0722f
C6298 VIN.n807 VSS 0.0722f
C6299 VIN.n808 VSS 0.0722f
C6300 VIN.n809 VSS 0.0722f
C6301 VIN.n810 VSS 0.0722f
C6302 VIN.n811 VSS 0.0722f
C6303 VIN.n812 VSS 0.0722f
C6304 VIN.n813 VSS 0.0722f
C6305 VIN.n814 VSS 0.0722f
C6306 VIN.n815 VSS 0.06829f
C6307 VIN.n816 VSS 0.06924f
C6308 VIN.n817 VSS 0.08298f
C6309 VIN.n818 VSS 0.16191f
C6310 VIN.n819 VSS 0.08298f
C6311 VIN.n820 VSS 0.05768f
C6312 VIN.t1258 VSS 0.00879f
C6313 VIN.t370 VSS 0.00882f
C6314 VIN.t2070 VSS 0.00879f
C6315 VIN.t1204 VSS 0.00882f
C6316 VIN.t1536 VSS 0.00879f
C6317 VIN.t672 VSS 0.00882f
C6318 VIN.t876 VSS 0.00879f
C6319 VIN.t2032 VSS 0.00882f
C6320 VIN.t1874 VSS 0.00879f
C6321 VIN.t1014 VSS 0.00882f
C6322 VIN.t1212 VSS 0.00879f
C6323 VIN.t315 VSS 0.00882f
C6324 VIN.t2028 VSS 0.00879f
C6325 VIN.t1158 VSS 0.00882f
C6326 VIN.t1126 VSS 0.00879f
C6327 VIN.t223 VSS 0.00882f
C6328 VIN.t1964 VSS 0.00879f
C6329 VIN.t1102 VSS 0.00882f
C6330 VIN.t1442 VSS 0.00879f
C6331 VIN.t574 VSS 0.00882f
C6332 VIN.t768 VSS 0.00879f
C6333 VIN.t1934 VSS 0.00882f
C6334 VIN.t219 VSS 0.00879f
C6335 VIN.t1406 VSS 0.00882f
C6336 VIN.t566 VSS 0.00879f
C6337 VIN.t1720 VSS 0.00882f
C6338 VIN.t1924 VSS 0.00879f
C6339 VIN.t1054 VSS 0.00882f
C6340 VIN.t1398 VSS 0.00879f
C6341 VIN.t532 VSS 0.00882f
C6342 VIN.t720 VSS 0.00879f
C6343 VIN.t1876 VSS 0.00882f
C6344 VIN.t1716 VSS 0.00879f
C6345 VIN.t848 VSS 0.00882f
C6346 VIN.t522 VSS 0.00879f
C6347 VIN.t1668 VSS 0.00882f
C6348 VIN.t530 VSS 0.00879f
C6349 VIN.t1674 VSS 0.00882f
C6350 VIN.t1358 VSS 0.00879f
C6351 VIN.t488 VSS 0.00882f
C6352 VIN.t129 VSS 0.00879f
C6353 VIN.t1334 VSS 0.00882f
C6354 VIN.t1664 VSS 0.00879f
C6355 VIN.t802 VSS 0.00882f
C6356 VIN.t476 VSS 0.00879f
C6357 VIN.t1618 VSS 0.00882f
C6358 VIN.t486 VSS 0.00879f
C6359 VIN.t1626 VSS 0.00882f
C6360 VIN.t1318 VSS 0.00879f
C6361 VIN.t448 VSS 0.00882f
C6362 VIN.t800 VSS 0.00879f
C6363 VIN.t1958 VSS 0.00882f
C6364 VIN.t1616 VSS 0.00879f
C6365 VIN.t750 VSS 0.00882f
C6366 VIN.t436 VSS 0.00879f
C6367 VIN.t1568 VSS 0.00882f
C6368 VIN.t1710 VSS 0.00879f
C6369 VIN.t842 VSS 0.00882f
C6370 VIN.t2040 VSS 0.00879f
C6371 VIN.t1178 VSS 0.00882f
C6372 VIN.t812 VSS 0.00879f
C6373 VIN.t1972 VSS 0.00882f
C6374 VIN.t2016 VSS 0.00879f
C6375 VIN.t1154 VSS 0.00882f
C6376 VIN.n821 VSS 0.04791f
C6377 VIN.n822 VSS 0.0722f
C6378 VIN.n823 VSS 0.0722f
C6379 VIN.n824 VSS 0.0722f
C6380 VIN.n825 VSS 0.0722f
C6381 VIN.n826 VSS 0.0722f
C6382 VIN.n827 VSS 0.0722f
C6383 VIN.n828 VSS 0.0722f
C6384 VIN.n829 VSS 0.0722f
C6385 VIN.n830 VSS 0.0722f
C6386 VIN.n831 VSS 0.0722f
C6387 VIN.n832 VSS 0.0722f
C6388 VIN.n833 VSS 0.0722f
C6389 VIN.n834 VSS 0.0722f
C6390 VIN.n835 VSS 0.0722f
C6391 VIN.n836 VSS 0.0722f
C6392 VIN.n837 VSS 0.0722f
C6393 VIN.n838 VSS 0.0722f
C6394 VIN.n839 VSS 0.0722f
C6395 VIN.n840 VSS 0.0722f
C6396 VIN.n841 VSS 0.0722f
C6397 VIN.n842 VSS 0.0722f
C6398 VIN.n843 VSS 0.0722f
C6399 VIN.n844 VSS 0.0722f
C6400 VIN.n845 VSS 0.0722f
C6401 VIN.n846 VSS 0.0722f
C6402 VIN.n847 VSS 0.0722f
C6403 VIN.n848 VSS 0.0722f
C6404 VIN.n849 VSS 0.0722f
C6405 VIN.n850 VSS 0.0722f
C6406 VIN.n851 VSS 0.0722f
C6407 VIN.n852 VSS 0.08362f
C6408 VIN.n853 VSS 0.085f
C6409 VIN.n854 VSS 0.08298f
C6410 VIN.n855 VSS 0.16191f
C6411 VIN.n856 VSS 0.08298f
C6412 VIN.t458 VSS 0.00882f
C6413 VIN.t1480 VSS 0.00879f
C6414 VIN.t1792 VSS 0.00882f
C6415 VIN.t806 VSS 0.00879f
C6416 VIN.t1294 VSS 0.00882f
C6417 VIN.t275 VSS 0.00879f
C6418 VIN.t604 VSS 0.00882f
C6419 VIN.t1646 VSS 0.00879f
C6420 VIN.t928 VSS 0.00882f
C6421 VIN.t1954 VSS 0.00879f
C6422 VIN.t405 VSS 0.00882f
C6423 VIN.t1438 VSS 0.00879f
C6424 VIN.t1744 VSS 0.00882f
C6425 VIN.t756 VSS 0.00879f
C6426 VIN.t850 VSS 0.00882f
C6427 VIN.t1890 VSS 0.00879f
C6428 VIN.t1684 VSS 0.00882f
C6429 VIN.t694 VSS 0.00879f
C6430 VIN.t1184 VSS 0.00882f
C6431 VIN.t163 VSS 0.00879f
C6432 VIN.t1994 VSS 0.00882f
C6433 VIN.t1020 VSS 0.00879f
C6434 VIN.t1342 VSS 0.00882f
C6435 VIN.t326 VSS 0.00879f
C6436 VIN.t804 VSS 0.00882f
C6437 VIN.t1834 VSS 0.00879f
C6438 VIN.t1644 VSS 0.00882f
C6439 VIN.t650 VSS 0.00879f
C6440 VIN.t1138 VSS 0.00882f
C6441 VIN.t89 VSS 0.00879f
C6442 VIN.t1950 VSS 0.00882f
C6443 VIN.t962 VSS 0.00879f
C6444 VIN.t1288 VSS 0.00882f
C6445 VIN.t266 VSS 0.00879f
C6446 VIN.t221 VSS 0.00882f
C6447 VIN.t1300 VSS 0.00879f
C6448 VIN.t1586 VSS 0.00882f
C6449 VIN.t614 VSS 0.00879f
C6450 VIN.t1088 VSS 0.00882f
C6451 VIN.t6 VSS 0.00879f
C6452 VIN.t1912 VSS 0.00882f
C6453 VIN.t922 VSS 0.00879f
C6454 VIN.t1404 VSS 0.00882f
C6455 VIN.t419 VSS 0.00879f
C6456 VIN.t175 VSS 0.00882f
C6457 VIN.t1246 VSS 0.00879f
C6458 VIN.t1532 VSS 0.00882f
C6459 VIN.t562 VSS 0.00879f
C6460 VIN.t1042 VSS 0.00882f
C6461 VIN.t2072 VSS 0.00879f
C6462 VIN.t1356 VSS 0.00882f
C6463 VIN.t351 VSS 0.00879f
C6464 VIN.t1372 VSS 0.00882f
C6465 VIN.t364 VSS 0.00879f
C6466 VIN.t107 VSS 0.00882f
C6467 VIN.t1200 VSS 0.00879f
C6468 VIN.t1448 VSS 0.00882f
C6469 VIN.t468 VSS 0.00879f
C6470 VIN.t1758 VSS 0.00882f
C6471 VIN.t774 VSS 0.00879f
C6472 VIN.t1244 VSS 0.00882f
C6473 VIN.t225 VSS 0.00879f
C6474 VIN.t550 VSS 0.00882f
C6475 VIN.t1570 VSS 0.00879f
C6476 VIN.n857 VSS 0.07856f
C6477 VIN.n858 VSS 0.0722f
C6478 VIN.n859 VSS 0.0722f
C6479 VIN.n860 VSS 0.0722f
C6480 VIN.n861 VSS 0.0722f
C6481 VIN.n862 VSS 0.0722f
C6482 VIN.n863 VSS 0.0722f
C6483 VIN.n864 VSS 0.0722f
C6484 VIN.n865 VSS 0.0722f
C6485 VIN.n866 VSS 0.0722f
C6486 VIN.n867 VSS 0.0722f
C6487 VIN.n868 VSS 0.0722f
C6488 VIN.n869 VSS 0.0722f
C6489 VIN.n870 VSS 0.0722f
C6490 VIN.n871 VSS 0.0722f
C6491 VIN.n872 VSS 0.0722f
C6492 VIN.n873 VSS 0.0722f
C6493 VIN.n874 VSS 0.0722f
C6494 VIN.n875 VSS 0.0722f
C6495 VIN.n876 VSS 0.0722f
C6496 VIN.n877 VSS 0.0722f
C6497 VIN.n878 VSS 0.0722f
C6498 VIN.n879 VSS 0.0722f
C6499 VIN.n880 VSS 0.0722f
C6500 VIN.n881 VSS 0.0722f
C6501 VIN.n882 VSS 0.0722f
C6502 VIN.n883 VSS 0.0722f
C6503 VIN.n884 VSS 0.0722f
C6504 VIN.n885 VSS 0.0722f
C6505 VIN.n886 VSS 0.0722f
C6506 VIN.n887 VSS 0.0722f
C6507 VIN.n888 VSS 0.06829f
C6508 VIN.n889 VSS 0.07589f
C6509 VIN.n890 VSS 0.08298f
C6510 VIN.n891 VSS 0.38988f
C6511 VIN.n892 VSS 0.08298f
C6512 VIN.t1410 VSS 0.0088f
C6513 VIN.t1134 VSS 0.00881f
C6514 VIN.t180 VSS 0.0088f
C6515 VIN.t1946 VSS 0.00881f
C6516 VIN.t1712 VSS 0.0088f
C6517 VIN.t1436 VSS 0.00881f
C6518 VIN.t1056 VSS 0.0088f
C6519 VIN.t752 VSS 0.00881f
C6520 VIN.t2046 VSS 0.0088f
C6521 VIN.t1752 VSS 0.00881f
C6522 VIN.t1380 VSS 0.0088f
C6523 VIN.t1090 VSS 0.00881f
C6524 VIN.t115 VSS 0.0088f
C6525 VIN.t1914 VSS 0.00881f
C6526 VIN.t1302 VSS 0.0088f
C6527 VIN.t1012 VSS 0.00881f
C6528 VIN.t27 VSS 0.0088f
C6529 VIN.t1842 VSS 0.00881f
C6530 VIN.t1604 VSS 0.0088f
C6531 VIN.t1344 VSS 0.00881f
C6532 VIN.t944 VSS 0.0088f
C6533 VIN.t644 VSS 0.00881f
C6534 VIN.t421 VSS 0.0088f
C6535 VIN.t79 VSS 0.00881f
C6536 VIN.t730 VSS 0.0088f
C6537 VIN.t460 VSS 0.00881f
C6538 VIN.t2092 VSS 0.0088f
C6539 VIN.t1794 VSS 0.00881f
C6540 VIN.t1546 VSS 0.0088f
C6541 VIN.t1290 VSS 0.00881f
C6542 VIN.t892 VSS 0.0088f
C6543 VIN.t606 VSS 0.00881f
C6544 VIN.t1888 VSS 0.0088f
C6545 VIN.t1594 VSS 0.00881f
C6546 VIN.t676 VSS 0.0088f
C6547 VIN.t403 VSS 0.00881f
C6548 VIN.t682 VSS 0.0088f
C6549 VIN.t407 VSS 0.00881f
C6550 VIN.t1496 VSS 0.0088f
C6551 VIN.t1234 VSS 0.00881f
C6552 VIN.t321 VSS 0.0088f
C6553 VIN.t2074 VSS 0.00881f
C6554 VIN.t1832 VSS 0.0088f
C6555 VIN.t1538 VSS 0.00881f
C6556 VIN.t628 VSS 0.0088f
C6557 VIN.t345 VSS 0.00881f
C6558 VIN.t636 VSS 0.0088f
C6559 VIN.t353 VSS 0.00881f
C6560 VIN.t1460 VSS 0.0088f
C6561 VIN.t1192 VSS 0.00881f
C6562 VIN.t974 VSS 0.0088f
C6563 VIN.t678 VSS 0.00881f
C6564 VIN.t1786 VSS 0.0088f
C6565 VIN.t1490 VSS 0.00881f
C6566 VIN.t590 VSS 0.0088f
C6567 VIN.t286 VSS 0.00881f
C6568 VIN.t1884 VSS 0.0088f
C6569 VIN.t1592 VSS 0.00881f
C6570 VIN.t143 VSS 0.0088f
C6571 VIN.t1918 VSS 0.00881f
C6572 VIN.t988 VSS 0.0088f
C6573 VIN.t684 VSS 0.00881f
C6574 VIN.t110 VSS 0.0088f
C6575 VIN.t1898 VSS 0.00881f
C6576 VIN.n893 VSS 0.04791f
C6577 VIN.n894 VSS 0.0722f
C6578 VIN.n895 VSS 0.0722f
C6579 VIN.n896 VSS 0.0722f
C6580 VIN.n897 VSS 0.0722f
C6581 VIN.n898 VSS 0.0722f
C6582 VIN.n899 VSS 0.0722f
C6583 VIN.n900 VSS 0.0722f
C6584 VIN.n901 VSS 0.0722f
C6585 VIN.n902 VSS 0.0722f
C6586 VIN.n903 VSS 0.0722f
C6587 VIN.n904 VSS 0.0722f
C6588 VIN.n905 VSS 0.0722f
C6589 VIN.n906 VSS 0.0722f
C6590 VIN.n907 VSS 0.0722f
C6591 VIN.n908 VSS 0.0722f
C6592 VIN.n909 VSS 0.0722f
C6593 VIN.n910 VSS 0.0722f
C6594 VIN.n911 VSS 0.0722f
C6595 VIN.n912 VSS 0.0722f
C6596 VIN.n913 VSS 0.0722f
C6597 VIN.n914 VSS 0.0722f
C6598 VIN.n915 VSS 0.0722f
C6599 VIN.n916 VSS 0.0722f
C6600 VIN.n917 VSS 0.0722f
C6601 VIN.n918 VSS 0.0722f
C6602 VIN.n919 VSS 0.0722f
C6603 VIN.n920 VSS 0.0722f
C6604 VIN.n921 VSS 0.0722f
C6605 VIN.n922 VSS 0.0722f
C6606 VIN.n923 VSS 0.0722f
C6607 VIN.n924 VSS 0.08362f
C6608 VIN.n925 VSS 0.08457f
C6609 VIN.t1312 VSS 0.01501f
C6610 VIN.t1986 VSS 0.00879f
C6611 VIN.n926 VSS 0.05899f
C6612 VIN.t494 VSS 0.00879f
C6613 VIN.n927 VSS 0.04024f
C6614 VIN.t150 VSS 0.00879f
C6615 VIN.n928 VSS 0.04024f
C6616 VIN.t914 VSS 0.00879f
C6617 VIN.n929 VSS 0.04024f
C6618 VIN.t0 VSS 0.00879f
C6619 VIN.n930 VSS 0.04024f
C6620 VIN.t2108 VSS 0.00879f
C6621 VIN.n931 VSS 0.04024f
C6622 VIN.t1778 VSS 0.00879f
C6623 VIN.n932 VSS 0.04024f
C6624 VIN.t262 VSS 0.00879f
C6625 VIN.n933 VSS 0.04024f
C6626 VIN.t956 VSS 0.00879f
C6627 VIN.n934 VSS 0.04024f
C6628 VIN.t77 VSS 0.00879f
C6629 VIN.n935 VSS 0.04024f
C6630 VIN.t622 VSS 0.00879f
C6631 VIN.n936 VSS 0.04024f
C6632 VIN.t1830 VSS 0.00879f
C6633 VIN.n937 VSS 0.04024f
C6634 VIN.t317 VSS 0.00879f
C6635 VIN.n938 VSS 0.04024f
C6636 VIN.t1010 VSS 0.00879f
C6637 VIN.n939 VSS 0.04024f
C6638 VIN.t2034 VSS 0.00879f
C6639 VIN.n940 VSS 0.04024f
C6640 VIN.t670 VSS 0.00879f
C6641 VIN.n941 VSS 0.04024f
C6642 VIN.t1880 VSS 0.00879f
C6643 VIN.n942 VSS 0.04024f
C6644 VIN.t372 VSS 0.00879f
C6645 VIN.n943 VSS 0.04024f
C6646 VIN.t1540 VSS 0.00879f
C6647 VIN.n944 VSS 0.04024f
C6648 VIN.t2084 VSS 0.00879f
C6649 VIN.n945 VSS 0.04024f
C6650 VIN.t724 VSS 0.00879f
C6651 VIN.n946 VSS 0.04024f
C6652 VIN.t1940 VSS 0.00879f
C6653 VIN.n947 VSS 0.04024f
C6654 VIN.t430 VSS 0.00879f
C6655 VIN.n948 VSS 0.04024f
C6656 VIN.t1596 VSS 0.00879f
C6657 VIN.n949 VSS 0.04024f
C6658 VIN.t490 VSS 0.00879f
C6659 VIN.n950 VSS 0.04024f
C6660 VIN.t1168 VSS 0.00879f
C6661 VIN.n951 VSS 0.04024f
C6662 VIN.t1658 VSS 0.00879f
C6663 VIN.n952 VSS 0.04024f
C6664 VIN.t1374 VSS 0.00879f
C6665 VIN.n953 VSS 0.04024f
C6666 VIN.t2044 VSS 0.00879f
C6667 VIN.n954 VSS 0.04024f
C6668 VIN.t526 VSS 0.00879f
C6669 VIN.n955 VSS 0.04024f
C6670 VIN.t1218 VSS 0.00879f
C6671 VIN.n956 VSS 0.0379f
C6672 VIN.n957 VSS 0.09914f
C6673 VIN.t2137 VSS 0.02935f
C6674 VIN.t2139 VSS 0.02935f
C6675 VIN.n958 VSS 0.07647f
C6676 VIN.t2130 VSS 0.0044f
C6677 VIN.t2131 VSS 0.0044f
C6678 VIN.n959 VSS 0.01121f
C6679 VIN.n960 VSS 0.62376f
C6680 VIN.t2133 VSS 0.02935f
C6681 VIN.t2135 VSS 0.02935f
C6682 VIN.n961 VSS 0.07647f
C6683 VIN.t2128 VSS 0.0044f
C6684 VIN.t2129 VSS 0.0044f
C6685 VIN.n962 VSS 0.01121f
C6686 VIN.n963 VSS 0.72206f
C6687 VIN.n964 VSS 0.01966f
C6688 VIN.n965 VSS 0.04558f
C6689 VIN.n967 VSS 0.18619f
C6690 VIN.n968 VSS 0.00849f
C6691 VIN.n969 VSS 0.05561f
C6692 VIN.t2154 VSS 3.05797f
C6693 VIN.t2153 VSS 2.79548f
C6694 VIN.n970 VSS 0.49145f
C6695 VIN.t2152 VSS 2.79548f
C6696 VIN.n971 VSS 0.37697f
C6697 VIN.t2155 VSS 2.79548f
C6698 VIN.n972 VSS 0.39566f
C6699 VIN.n973 VSS 0.25453f
C6700 VIN.n974 VSS 0.08395f
C6701 VIN.n975 VSS 0.08317f
C6702 VIN.n976 VSS 0.02949f
C6703 VIN.n977 VSS 0.02949f
C6704 VIN.n978 VSS 0.03441f
C6705 VIN.n979 VSS 0.17891f
C6706 VIN.n980 VSS 0.0748f
C6707 VIN.n981 VSS 0.06423f
C6708 VIN.n982 VSS 0.10119f
C6709 VIN.n983 VSS 0.07365f
C6710 VIN.n984 VSS 4.24299f
C6711 VIN.n985 VSS 5.85454f
C6712 VIN.n986 VSS 0.0863f
C6713 VIN.n987 VSS 0.08298f
C6714 VIN.n988 VSS 0.07893f
C6715 VIN.n989 VSS 0.05161f
C6716 VIN.n990 VSS 0.08298f
C6717 VIN.n991 VSS 0.08298f
C6718 VIN.n992 VSS 0.16191f
C6719 VIN.n993 VSS 0.16191f
C6720 VIN.n994 VSS 0.08298f
C6721 VIN.n995 VSS 0.08298f
C6722 VIN.n996 VSS 0.06679f
C6723 VIN.n997 VSS 0.06924f
C6724 VIN.n998 VSS 0.06072f
C6725 VIN.n999 VSS 0.08298f
C6726 VIN.n1000 VSS 0.08298f
C6727 VIN.n1001 VSS 0.16191f
C6728 VIN.n1002 VSS 0.16191f
C6729 VIN.n1003 VSS 0.08298f
C6730 VIN.n1004 VSS 0.08298f
C6731 VIN.n1005 VSS 0.12707f
C6732 VIN.n1006 VSS 0.085f
C6733 VIN.n1007 VSS 0.08298f
C6734 VIN.n1008 VSS 0.08298f
C6735 VIN.n1009 VSS 0.16191f
C6736 VIN.n1010 VSS 0.16191f
C6737 VIN.n1011 VSS 0.08298f
C6738 VIN.n1012 VSS 0.08298f
C6739 VIN.n1013 VSS 0.06982f
C6740 VIN.n1014 VSS 0.07589f
C6741 VIN.n1015 VSS 0.08298f
C6742 VIN.n1016 VSS 0.08298f
C6743 VIN.n1017 VSS 0.16191f
C6744 VIN.n1018 VSS 0.16191f
C6745 VIN.n1019 VSS 0.08298f
C6746 VIN.n1020 VSS 0.08298f
C6747 VIN.n1021 VSS 0.085f
C6748 VIN.n1022 VSS 0.04857f
C6749 VIN.n1023 VSS 0.08298f
C6750 VIN.n1024 VSS 0.08298f
C6751 VIN.n1025 VSS 0.16191f
C6752 VIN.n1026 VSS 0.16191f
C6753 VIN.n1027 VSS 0.08298f
C6754 VIN.n1028 VSS 0.08298f
C6755 VIN.n1029 VSS 0.06375f
C6756 VIN.n1030 VSS 0.08457f
C6757 VIN.n1031 VSS 0.06375f
C6758 VIN.n1032 VSS 0.08298f
C6759 VIN.n1033 VSS 0.08298f
C6760 VIN.n1034 VSS 0.16191f
C6761 VIN.n1035 VSS 0.16191f
C6762 VIN.n1036 VSS 0.08298f
C6763 VIN.n1037 VSS 0.08298f
C6764 VIN.n1038 VSS 0.04554f
C6765 VIN.n1039 VSS 0.085f
C6766 VIN.n1040 VSS 0.08298f
C6767 VIN.n1041 VSS 0.08298f
C6768 VIN.n1042 VSS 3.3535f
C6769 VIN.n1043 VSS 0.12952f
C6770 VIN.n1044 VSS 0.16358f
C6771 VIN.n1045 VSS 0.07286f
C6772 VIN.n1046 VSS 0.07286f
C6773 VIN.n1047 VSS 0.06924f
C6774 VIN.n1048 VSS 0.05464f
C6775 VIN.n1049 VSS 0.16595f
C6776 VIN.n1050 VSS 0.16595f
C6777 VIN.n1051 VSS 0.16595f
C6778 VIN.n1052 VSS 0.04554f
C6779 VIN.n1053 VSS 0.08457f
C6780 VIN.n1054 VSS 0.08197f
C6781 VIN.n1055 VSS 0.06072f
C6782 VIN.n1056 VSS 0.16595f
C6783 VIN.n1057 VSS 0.16595f
C6784 VIN.n1058 VSS 0.06679f
C6785 VIN.n1059 VSS 0.07893f
C6786 VIN.n1060 VSS 0.08457f
C6787 VIN.n1061 VSS 0.04857f
C6788 VIN.n1062 VSS 0.16595f
C6789 VIN.n1063 VSS 0.16595f
C6790 VIN.n1064 VSS 0.16595f
C6791 VIN.n1065 VSS 0.05161f
C6792 VIN.n1066 VSS 0.06924f
C6793 VIN.n1067 VSS 0.07589f
C6794 VIN.n1068 VSS 0.06982f
C6795 VIN.n1069 VSS 0.16595f
C6796 VIN.n1070 VSS 0.16595f
C6797 VIN.n1071 VSS 0.18429f
C6798 VIN.n1072 VSS 0.06982f
C6799 VIN.n1073 VSS 0.1205f
C6800 VIN.t196 VSS 0.00879f
C6801 VIN.n1074 VSS 0.22953f
C6802 VIN.n1075 VSS 0.42753f
C6803 VIN.n1076 VSS 0.78183f
C6804 VIN.n1077 VSS 0.23783f
C6805 VIN.n1078 VSS 0.29169f
C6806 VIN.n1079 VSS 0.45213f
C6807 VIN.n1080 VSS 0.40368f
C6808 VIN.n1081 VSS 0.20023f
C6809 VIN.n1082 VSS 0.21493f
C6810 VIN.t1649 VSS 0.00774f
C6811 VIN.t142 VSS 0.00774f
C6812 VIN.t1225 VSS 0.00774f
C6813 VIN.t935 VSS 0.00774f
C6814 VIN.t1469 VSS 0.00774f
C6815 VIN.t1101 VSS 0.00774f
C6816 VIN.t172 VSS 0.00774f
C6817 VIN.t743 VSS 0.00774f
C6818 VIN.t358 VSS 0.00774f
C6819 VIN.t1383 VSS 0.00774f
C6820 VIN.t505 VSS 0.00774f
C6821 VIN.t1519 VSS 0.00774f
C6822 VIN.t635 VSS 0.00774f
C6823 VIN.t1793 VSS 0.00774f
C6824 VIN.t807 VSS 0.00774f
C6825 VIN.t527 VSS 0.00774f
C6826 VIN.t1947 VSS 0.00774f
C6827 VIN.n1083 VSS 0.08284f
C6828 VIN.t181 VSS 0.00774f
C6829 VIN.n1084 VSS 0.08863f
C6830 VIN.t1205 VSS 0.00774f
C6831 VIN.n1085 VSS 0.08863f
C6832 VIN.t2071 VSS 0.00774f
C6833 VIN.n1086 VSS 0.08863f
C6834 VIN.t941 VSS 0.00774f
C6835 VIN.n1087 VSS 0.08863f
C6836 VIN.t1927 VSS 0.00774f
C6837 VIN.n1088 VSS 0.08863f
C6838 VIN.t763 VSS 0.00774f
C6839 VIN.n1089 VSS 0.08863f
C6840 VIN.t304 VSS 0.00774f
C6841 VIN.n1090 VSS 0.08863f
C6842 VIN.t697 VSS 0.00774f
C6843 VIN.n1091 VSS 0.08863f
C6844 VIN.t106 VSS 0.00774f
C6845 VIN.n1092 VSS 0.08863f
C6846 VIN.t1051 VSS 0.00774f
C6847 VIN.n1093 VSS 0.08863f
C6848 VIN.t1429 VSS 0.00774f
C6849 VIN.n1094 VSS 0.08863f
C6850 VIN.t883 VSS 0.00774f
C6851 VIN.n1095 VSS 0.08863f
C6852 VIN.t1175 VSS 0.00774f
C6853 VIN.n1096 VSS 0.08863f
C6854 VIN.t64 VSS 0.00774f
C6855 VIN.n1097 VSS 0.08863f
C6856 VIN.t1591 VSS 0.00774f
C6857 VIN.n1098 VSS 0.0729f
C6858 VIN.n1099 VSS 0.23783f
C6859 VIN.n1100 VSS 0.18423f
C6860 VIN.n1101 VSS 0.2519f
C6861 VIN.n1102 VSS 0.45213f
C6862 VIN.t1338 VSS 0.00879f
C6863 VIN.n1103 VSS 0.22953f
C6864 VIN.n1104 VSS 0.43275f
C6865 VIN.n1105 VSS 0.42986f
C6866 VIN.n1106 VSS 0.3531f
C6867 VIN.n1107 VSS 0.23783f
C6868 VIN.n1108 VSS 0.09211f
C6869 VIN.n1109 VSS 0.24221f
C6870 VIN.n1110 VSS 0.22606f
C6871 VIN.t718 VSS 0.00879f
C6872 VIN.n1111 VSS 0.22953f
C6873 VIN.n1112 VSS 0.42306f
C6874 VIN.n1113 VSS 0.66132f
C6875 VIN.n1114 VSS 3.74673f
C6876 VIN.n1115 VSS 0.46377f
C6877 VIN.n1116 VSS 0.16887f
C6878 VIN.n1117 VSS 0.45213f
C6879 VIN.n1118 VSS 0.3068f
C6880 VIN.t1332 VSS 0.00879f
C6881 VIN.n1119 VSS 0.14879f
C6882 VIN.n1120 VSS 0.2196f
C6883 VIN.n1121 VSS 0.21493f
C6884 VIN.n1122 VSS 0.30705f
C6885 VIN.n1123 VSS 0.23783f
C6886 VIN.n1124 VSS 0.26099f
C6887 VIN.n1125 VSS 0.45213f
C6888 VIN.n1126 VSS 0.45213f
C6889 VIN.t1000 VSS 0.00879f
C6890 VIN.n1127 VSS 0.37485f
C6891 VIN.n1128 VSS 0.3531f
C6892 VIN.n1129 VSS 0.16887f
C6893 VIN.n1130 VSS 0.09966f
C6894 VIN.n1131 VSS 0.26099f
C6895 VIN.n1132 VSS 0.3068f
C6896 VIN.n1133 VSS 0.45213f
C6897 VIN.t390 VSS 0.00879f
C6898 VIN.n1134 VSS 0.22953f
C6899 VIN.n1135 VSS 0.23252f
C6900 VIN.n1136 VSS 0.38381f
C6901 VIN.n1137 VSS 0.23783f
C6902 VIN.n1138 VSS 0.24564f
C6903 VIN.n1139 VSS 0.21493f
C6904 VIN.n1140 VSS 0.22606f
C6905 VIN.n1141 VSS 0.24221f
C6906 VIN.n1142 VSS 0.23898f
C6907 VIN.n1143 VSS 0.38381f
C6908 VIN.n1144 VSS 0.23783f
C6909 VIN.n1145 VSS 0.26099f
C6910 VIN.n1146 VSS 0.43921f
C6911 VIN.n1147 VSS 0.45213f
C6912 VIN.t546 VSS 0.00879f
C6913 VIN.n1148 VSS 0.05191f
C6914 VIN.n1149 VSS 0.24544f
C6915 VIN.n1150 VSS 0.26099f
C6916 VIN.n1151 VSS 0.16887f
C6917 VIN.n1152 VSS 0.19177f
C6918 VIN.n1153 VSS 0.26099f
C6919 VIN.n1154 VSS 0.40368f
C6920 VIN.n1155 VSS 0.45213f
C6921 VIN.t198 VSS 0.00879f
C6922 VIN.n1156 VSS 0.22953f
C6923 VIN.n1157 VSS 0.2519f
C6924 VIN.n1158 VSS 0.41451f
C6925 VIN.n1159 VSS 0.23783f
C6926 VIN.n1160 VSS 0.12282f
C6927 VIN.n1161 VSS 0.21493f
C6928 VIN.n1162 VSS 0.22606f
C6929 VIN.n1163 VSS 0.33909f
C6930 VIN.t68 VSS 0.00879f
C6931 VIN.n1164 VSS 0.22953f
C6932 VIN.n1165 VSS 0.25836f
C6933 VIN.n1166 VSS 0.41451f
C6934 VIN.n1167 VSS 0.23783f
C6935 VIN.n1168 VSS 0.23028f
C6936 VIN.n1169 VSS 0.38381f
C6937 VIN.n1170 VSS 0.40368f
C6938 VIN.n1171 VSS 0.22606f
C6939 VIN.n1172 VSS 0.0872f
C6940 VIN.n1173 VSS 0.24564f
C6941 VIN.n1174 VSS 0.23783f
C6942 VIN.n1175 VSS 0.23028f
C6943 VIN.n1176 VSS 0.41337f
C6944 VIN.n1177 VSS 0.45213f
C6945 VIN.t1232 VSS 0.00879f
C6946 VIN.n1178 VSS 0.22953f
C6947 VIN.n1179 VSS 0.27128f
C6948 VIN.n1180 VSS 0.41451f
C6949 VIN.n1181 VSS 0.23783f
C6950 VIN.n1182 VSS 0.0307f
C6951 VIN.n1183 VSS 0.21493f
C6952 VIN.n1184 VSS 0.22606f
C6953 VIN.n1185 VSS 0.43598f
C6954 VIN.t1326 VSS 0.00879f
C6955 VIN.n1186 VSS 0.22953f
C6956 VIN.n1187 VSS 0.27773f
C6957 VIN.n1188 VSS 0.41451f
C6958 VIN.n1189 VSS 0.23783f
C6959 VIN.n1190 VSS 0.23028f
C6960 VIN.n1191 VSS 0.29169f
C6961 VIN.n1192 VSS 0.3068f
C6962 VIN.n1193 VSS 0.22606f
C6963 VIN.n1194 VSS 0.20346f
C6964 VIN.n1195 VSS 0.3531f
C6965 VIN.t999 VSS 0.00774f
C6966 VIN.t1529 VSS 0.00774f
C6967 VIN.t559 VSS 0.00774f
C6968 VIN.t249 VSS 0.00774f
C6969 VIN.t817 VSS 0.00774f
C6970 VIN.t445 VSS 0.00774f
C6971 VIN.t1551 VSS 0.00774f
C6972 VIN.t17 VSS 0.00774f
C6973 VIN.t1727 VSS 0.00774f
C6974 VIN.t691 VSS 0.00774f
C6975 VIN.t1851 VSS 0.00774f
C6976 VIN.t863 VSS 0.00774f
C6977 VIN.t1993 VSS 0.00774f
C6978 VIN.t1139 VSS 0.00774f
C6979 VIN.t90 VSS 0.00774f
C6980 VIN.t1881 VSS 0.00774f
C6981 VIN.t1291 VSS 0.00774f
C6982 VIN.n1196 VSS 0.08171f
C6983 VIN.t1547 VSS 0.00774f
C6984 VIN.n1197 VSS 0.08749f
C6985 VIN.t533 VSS 0.00774f
C6986 VIN.n1198 VSS 0.08749f
C6987 VIN.t1399 VSS 0.00774f
C6988 VIN.n1199 VSS 0.08749f
C6989 VIN.t245 VSS 0.00774f
C6990 VIN.n1200 VSS 0.08749f
C6991 VIN.t1261 VSS 0.00774f
C6992 VIN.n1201 VSS 0.08749f
C6993 VIN.t26 VSS 0.00774f
C6994 VIN.n1202 VSS 0.08749f
C6995 VIN.t1677 VSS 0.00774f
C6996 VIN.n1203 VSS 0.08749f
C6997 VIN.t2079 VSS 0.00774f
C6998 VIN.n1204 VSS 0.08749f
C6999 VIN.t1501 VSS 0.00774f
C7000 VIN.n1205 VSS 0.08749f
C7001 VIN.t389 VSS 0.00774f
C7002 VIN.n1206 VSS 0.08749f
C7003 VIN.t767 VSS 0.00774f
C7004 VIN.n1207 VSS 0.08749f
C7005 VIN.t193 VSS 0.00774f
C7006 VIN.n1208 VSS 0.08749f
C7007 VIN.t513 VSS 0.00774f
C7008 VIN.n1209 VSS 0.08749f
C7009 VIN.t1485 VSS 0.00774f
C7010 VIN.n1210 VSS 0.08749f
C7011 VIN.t951 VSS 0.00774f
C7012 VIN.n1211 VSS 0.07176f
C7013 VIN.n1212 VSS 0.23783f
C7014 VIN.n1213 VSS 0.23028f
C7015 VIN.n1214 VSS 0.39399f
C7016 VIN.n1215 VSS 0.45213f
C7017 VIN.t902 VSS 0.00879f
C7018 VIN.n1216 VSS 0.14879f
C7019 VIN.n1217 VSS 0.29065f
C7020 VIN.n1218 VSS 0.3531f
C7021 VIN.n1219 VSS 0.21493f
C7022 VIN.t903 VSS 0.00774f
C7023 VIN.t1441 VSS 0.00774f
C7024 VIN.t465 VSS 0.00774f
C7025 VIN.t139 VSS 0.00774f
C7026 VIN.t717 VSS 0.00774f
C7027 VIN.t331 VSS 0.00774f
C7028 VIN.t1467 VSS 0.00774f
C7029 VIN.t2031 VSS 0.00774f
C7030 VIN.t1629 VSS 0.00774f
C7031 VIN.t1505 VSS 0.00774f
C7032 VIN.t639 VSS 0.00774f
C7033 VIN.t1679 VSS 0.00774f
C7034 VIN.t791 VSS 0.00774f
C7035 VIN.t1951 VSS 0.00774f
C7036 VIN.t963 VSS 0.00774f
C7037 VIN.t671 VSS 0.00774f
C7038 VIN.t607 VSS 0.00774f
C7039 VIN.n1220 VSS 0.08228f
C7040 VIN.t893 VSS 0.00774f
C7041 VIN.n1221 VSS 0.08806f
C7042 VIN.t1877 VSS 0.00774f
C7043 VIN.n1222 VSS 0.08806f
C7044 VIN.t721 VSS 0.00774f
C7045 VIN.n1223 VSS 0.08806f
C7046 VIN.t1601 VSS 0.00774f
C7047 VIN.n1224 VSS 0.08806f
C7048 VIN.t569 VSS 0.00774f
C7049 VIN.n1225 VSS 0.08806f
C7050 VIN.t1445 VSS 0.00774f
C7051 VIN.n1226 VSS 0.08806f
C7052 VIN.t1097 VSS 0.00774f
C7053 VIN.n1227 VSS 0.08806f
C7054 VIN.t1457 VSS 0.00774f
C7055 VIN.n1228 VSS 0.08806f
C7056 VIN.t927 VSS 0.00774f
C7057 VIN.n1229 VSS 0.08806f
C7058 VIN.t1807 VSS 0.00774f
C7059 VIN.n1230 VSS 0.08806f
C7060 VIN.t125 VSS 0.00774f
C7061 VIN.n1231 VSS 0.08806f
C7062 VIN.t1643 VSS 0.00774f
C7063 VIN.n1232 VSS 0.08806f
C7064 VIN.t1931 VSS 0.00774f
C7065 VIN.n1233 VSS 0.08806f
C7066 VIN.t891 VSS 0.00774f
C7067 VIN.n1234 VSS 0.08806f
C7068 VIN.t333 VSS 0.00774f
C7069 VIN.n1235 VSS 0.07233f
C7070 VIN.n1236 VSS 0.23783f
C7071 VIN.n1237 VSS 0.09211f
C7072 VIN.n1238 VSS 0.3068f
C7073 VIN.n1239 VSS 0.35201f
C7074 VIN.t158 VSS 2.58157f
C7075 VIN.t46 VSS 1.69967f
C7076 VIN.t141 VSS 1.69967f
C7077 VIN.t63 VSS 1.69967f
C7078 VIN.t72 VSS 1.69967f
C7079 VIN.t228 VSS 1.69967f
C7080 VIN.t119 VSS 1.69967f
C7081 VIN.t55 VSS 1.69967f
C7082 VIN.t426 VSS 1.69967f
C7083 VIN.t92 VSS 1.69967f
C7084 VIN.t13 VSS 1.69967f
C7085 VIN.t240 VSS 1.69967f
C7086 VIN.t185 VSS 1.69967f
C7087 VIN.t116 VSS 1.69967f
C7088 VIN.t269 VSS 1.69967f
C7089 VIN.t211 VSS 1.69967f
C7090 VIN.t43 VSS 1.69967f
C7091 VIN.t28 VSS 1.69967f
C7092 VIN.t164 VSS 1.69967f
C7093 VIN.t101 VSS 1.69967f
C7094 VIN.t69 VSS 1.69967f
C7095 VIN.t66 VSS 1.69967f
C7096 VIN.t34 VSS 1.69967f
C7097 VIN.t40 VSS 1.69967f
C7098 VIN.t324 VSS 1.69967f
C7099 VIN.t395 VSS 1.69967f
C7100 VIN.t339 VSS 1.69967f
C7101 VIN.t360 VSS 1.69967f
C7102 VIN.t16 VSS 1.69967f
C7103 VIN.t25 VSS 1.69967f
C7104 VIN.t138 VSS 1.69967f
C7105 VIN.t124 VSS 1.27475f
C7106 VIN.t111 VSS 2.58157f
C7107 VIN.t52 VSS 1.69967f
C7108 VIN.t82 VSS 1.69967f
C7109 VIN.t4 VSS 1.69967f
C7110 VIN.t144 VSS 1.69967f
C7111 VIN.t301 VSS 1.69967f
C7112 VIN.t233 VSS 1.69967f
C7113 VIN.t98 VSS 1.69967f
C7114 VIN.t49 VSS 1.69967f
C7115 VIN.t108 VSS 1.69967f
C7116 VIN.t178 VSS 1.69967f
C7117 VIN.t1 VSS 1.69967f
C7118 VIN.t75 VSS 1.69967f
C7119 VIN.t167 VSS 1.69967f
C7120 VIN.t135 VSS 1.69967f
C7121 VIN.t306 VSS 1.69967f
C7122 VIN.t37 VSS 1.69967f
C7123 VIN.t22 VSS 1.69967f
C7124 VIN.t10 VSS 1.69967f
C7125 VIN.t87 VSS 1.69967f
C7126 VIN.t161 VSS 1.69967f
C7127 VIN.t31 VSS 1.69967f
C7128 VIN.t130 VSS 1.69967f
C7129 VIN.t155 VSS 1.69967f
C7130 VIN.t190 VSS 1.69967f
C7131 VIN.t7 VSS 1.69967f
C7132 VIN.t313 VSS 1.69967f
C7133 VIN.t278 VSS 1.69967f
C7134 VIN.t127 VSS 1.69967f
C7135 VIN.t19 VSS 1.69967f
C7136 VIN.t95 VSS 1.69967f
C7137 VIN.t58 VSS 1.27475f
C7138 VIN.n1240 VSS 1.78969f
C7139 VIN.n1241 VSS 1.16592f
C7140 VIN.n1242 VSS 0.17116f
C7141 VIN.n1243 VSS 0.42986f
C7142 VIN.n1244 VSS 0.23028f
C7143 VIN.n1245 VSS 0.36493f
C7144 VIN.n1246 VSS 0.22606f
C7145 VIN.n1247 VSS 0.19958f
C7146 VIN.n1248 VSS 0.23028f
C7147 VIN.n1249 VSS 0.42986f
C7148 VIN.n1250 VSS 0.30357f
C7149 VIN.t648 VSS 0.00879f
C7150 VIN.n1251 VSS 0.22953f
C7151 VIN.n1252 VSS 0.37462f
C7152 VIN.n1253 VSS 0.08397f
C7153 VIN.n1254 VSS 0.27451f
C7154 VIN.n1255 VSS 0.45213f
C7155 VIN.n1256 VSS 0.41451f
C7156 VIN.n1257 VSS 0.23783f
C7157 VIN.t649 VSS 0.00774f
C7158 VIN.t611 VSS 0.00774f
C7159 VIN.n1258 VSS 0.07233f
C7160 VIN.t1217 VSS 0.00774f
C7161 VIN.t1167 VSS 0.00774f
C7162 VIN.n1259 VSS 0.08806f
C7163 VIN.t188 VSS 0.00774f
C7164 VIN.t128 VSS 0.00774f
C7165 VIN.n1260 VSS 0.08806f
C7166 VIN.t1957 VSS 0.00774f
C7167 VIN.t1917 VSS 0.00774f
C7168 VIN.n1261 VSS 0.08806f
C7169 VIN.t493 VSS 0.00774f
C7170 VIN.t451 VSS 0.00774f
C7171 VIN.n1262 VSS 0.08806f
C7172 VIN.t20 VSS 0.00774f
C7173 VIN.t2081 VSS 0.00774f
C7174 VIN.n1263 VSS 0.08806f
C7175 VIN.t1237 VSS 0.00774f
C7176 VIN.t1195 VSS 0.00774f
C7177 VIN.n1264 VSS 0.08806f
C7178 VIN.t1777 VSS 0.00774f
C7179 VIN.t1733 VSS 0.00774f
C7180 VIN.n1265 VSS 0.08806f
C7181 VIN.t1401 VSS 0.00774f
C7182 VIN.t1361 VSS 0.00774f
C7183 VIN.n1266 VSS 0.08806f
C7184 VIN.t1847 VSS 0.00774f
C7185 VIN.t1253 VSS 0.00774f
C7186 VIN.n1267 VSS 0.08806f
C7187 VIN.t977 VSS 0.00774f
C7188 VIN.t367 VSS 0.00774f
C7189 VIN.n1268 VSS 0.08806f
C7190 VIN.t2005 VSS 0.00774f
C7191 VIN.t1409 VSS 0.00774f
C7192 VIN.n1269 VSS 0.08806f
C7193 VIN.t1125 VSS 0.00774f
C7194 VIN.t523 VSS 0.00774f
C7195 VIN.n1270 VSS 0.08806f
C7196 VIN.t222 VSS 0.00774f
C7197 VIN.t1669 VSS 0.00774f
C7198 VIN.n1271 VSS 0.08806f
C7199 VIN.t1301 VSS 0.00774f
C7200 VIN.t677 VSS 0.00774f
C7201 VIN.n1272 VSS 0.08806f
C7202 VIN.t1011 VSS 0.00774f
C7203 VIN.t404 VSS 0.00774f
C7204 VIN.n1273 VSS 0.12996f
C7205 VIN.n1274 VSS 0.16754f
C7206 VIN.n1275 VSS 0.06216f
C7207 VIN.n1276 VSS 0.057f
C7208 VIN.t2143 VSS 0.00692f
C7209 VIN.t2151 VSS 0.00692f
C7210 VIN.n1277 VSS 0.01918f
C7211 VIN.t2148 VSS 0.00692f
C7212 VIN.t2145 VSS 0.00692f
C7213 VIN.n1278 VSS 0.01918f
C7214 VIN.n1279 VSS 0.06939f
C7215 VIN.t261 VSS 0.00774f
C7216 VIN.t203 VSS 0.00774f
C7217 VIN.n1280 VSS 0.08749f
C7218 VIN.t1331 VSS 0.00774f
C7219 VIN.t1279 VSS 0.00774f
C7220 VIN.n1281 VSS 0.08749f
C7221 VIN.t1041 VSS 0.00774f
C7222 VIN.t995 VSS 0.00774f
C7223 VIN.n1282 VSS 0.08749f
C7224 VIN.t1575 VSS 0.00774f
C7225 VIN.t1523 VSS 0.00774f
C7226 VIN.n1283 VSS 0.08749f
C7227 VIN.t1203 VSS 0.00774f
C7228 VIN.t1157 VSS 0.00774f
C7229 VIN.n1284 VSS 0.08749f
C7230 VIN.t291 VSS 0.00774f
C7231 VIN.t236 VSS 0.00774f
C7232 VIN.n1285 VSS 0.08749f
C7233 VIN.t857 VSS 0.00774f
C7234 VIN.t811 VSS 0.00774f
C7235 VIN.n1286 VSS 0.08749f
C7236 VIN.t479 VSS 0.00774f
C7237 VIN.t439 VSS 0.00774f
C7238 VIN.n1287 VSS 0.08749f
C7239 VIN.t647 VSS 0.00774f
C7240 VIN.t2087 VSS 0.00774f
C7241 VIN.n1288 VSS 0.08749f
C7242 VIN.t1803 VSS 0.00774f
C7243 VIN.t1215 VSS 0.00774f
C7244 VIN.n1289 VSS 0.08749f
C7245 VIN.t821 VSS 0.00774f
C7246 VIN.t191 VSS 0.00774f
C7247 VIN.n1290 VSS 0.08749f
C7248 VIN.t1949 VSS 0.00774f
C7249 VIN.t1359 VSS 0.00774f
C7250 VIN.n1291 VSS 0.08749f
C7251 VIN.t1089 VSS 0.00774f
C7252 VIN.t489 VSS 0.00774f
C7253 VIN.n1292 VSS 0.08749f
C7254 VIN.t8 VSS 0.00774f
C7255 VIN.t1497 VSS 0.00774f
C7256 VIN.n1293 VSS 0.08749f
C7257 VIN.t1831 VSS 0.00774f
C7258 VIN.t1235 VSS 0.00774f
C7259 VIN.n1294 VSS 0.10068f
C7260 VIN.n1295 VSS 0.08506f
C7261 VIN.t1655 VSS 0.00774f
C7262 VIN.t1781 VSS 0.00774f
C7263 VIN.n1296 VSS 0.07233f
C7264 VIN.t156 VSS 0.00774f
C7265 VIN.t297 VSS 0.00774f
C7266 VIN.n1297 VSS 0.08806f
C7267 VIN.t1229 VSS 0.00774f
C7268 VIN.t1369 VSS 0.00774f
C7269 VIN.n1298 VSS 0.08806f
C7270 VIN.t947 VSS 0.00774f
C7271 VIN.t1073 VSS 0.00774f
C7272 VIN.n1299 VSS 0.08806f
C7273 VIN.t1479 VSS 0.00774f
C7274 VIN.t1609 VSS 0.00774f
C7275 VIN.n1300 VSS 0.08806f
C7276 VIN.t1115 VSS 0.00774f
C7277 VIN.t1239 VSS 0.00774f
C7278 VIN.n1301 VSS 0.08806f
C7279 VIN.t183 VSS 0.00774f
C7280 VIN.t342 VSS 0.00774f
C7281 VIN.n1302 VSS 0.08806f
C7282 VIN.t759 VSS 0.00774f
C7283 VIN.t901 VSS 0.00774f
C7284 VIN.n1303 VSS 0.08806f
C7285 VIN.t381 VSS 0.00774f
C7286 VIN.t515 VSS 0.00774f
C7287 VIN.n1304 VSS 0.08806f
C7288 VIN.t1465 VSS 0.00774f
C7289 VIN.t897 VSS 0.00774f
C7290 VIN.n1305 VSS 0.08806f
C7291 VIN.t599 VSS 0.00774f
C7292 VIN.t2051 VSS 0.00774f
C7293 VIN.n1306 VSS 0.08806f
C7294 VIN.t1635 VSS 0.00774f
C7295 VIN.t1069 VSS 0.00774f
C7296 VIN.n1307 VSS 0.08806f
C7297 VIN.t741 VSS 0.00774f
C7298 VIN.t131 VSS 0.00774f
C7299 VIN.n1308 VSS 0.08806f
C7300 VIN.t1913 VSS 0.00774f
C7301 VIN.t1335 VSS 0.00774f
C7302 VIN.n1309 VSS 0.08806f
C7303 VIN.t923 VSS 0.00774f
C7304 VIN.t322 VSS 0.00774f
C7305 VIN.n1310 VSS 0.08806f
C7306 VIN.t623 VSS 0.00774f
C7307 VIN.t2075 VSS 0.00774f
C7308 VIN.n1311 VSS 0.10124f
C7309 VIN.n1312 VSS 0.08361f
C7310 VIN.t2147 VSS 0.00692f
C7311 VIN.t2149 VSS 0.00692f
C7312 VIN.n1313 VSS 0.01918f
C7313 VIN.n1314 VSS 0.06636f
C7314 VIN.n1315 VSS 0.05556f
C7315 VIN.n1316 VSS 0.05556f
C7316 VIN.t2144 VSS 0.52107f
C7317 VIN.n1317 VSS 0.05473f
C7318 VIN.n1318 VSS 0.08144f
C7319 VIN.t2146 VSS 0.52107f
C7320 VIN.t2134 VSS 0.69476f
C7321 VIN.t2132 VSS 0.69476f
C7322 VIN.t2142 VSS 0.74354f
C7323 VIN.n1319 VSS 0.60303f
C7324 VIN.n1320 VSS 0.08145f
C7325 VIN.t2136 VSS 0.69476f
C7326 VIN.t2138 VSS 0.69476f
C7327 VIN.t2140 VSS 0.74354f
C7328 VIN.n1321 VSS 0.60303f
C7329 VIN.n1322 VSS 0.08145f
C7330 VIN.n1323 VSS 0.02862f
C7331 VIN.n1324 VSS 0.30345f
C7332 VIN.n1325 VSS 0.13048f
C7333 VIN.n1326 VSS 0.17097f
C7334 VIN.n1327 VSS 0.18024f
C7335 VIN.n1328 VSS 0.32879f
C7336 VIN.n1329 VSS 0.45011f
C7337 VIN.n1330 VSS 0.08144f
C7338 VIN.n1331 VSS 0.34738f
C7339 VIN.n1332 VSS 0.05473f
C7340 VIN.n1333 VSS 0.02819f
C7341 VIN.n1334 VSS 0.02544f
C7342 VIN.n1335 VSS 0.05782f
C7343 VIN.n1336 VSS 0.03614f
C7344 VIN.n1337 VSS 0.04265f
C7345 VIN.n1338 VSS 0.04265f
C7346 VIN.n1339 VSS 0.06795f
C7347 VIN.n1340 VSS 0.04467f
C7348 VIN.n1341 VSS 0.03325f
C7349 VIN.n1342 VSS 0.08361f
C7350 VIN.t408 VSS 0.00774f
C7351 VIN.n1343 VSS 0.10068f
C7352 VIN.t683 VSS 0.00774f
C7353 VIN.n1344 VSS 0.08749f
C7354 VIN.t1675 VSS 0.00774f
C7355 VIN.n1345 VSS 0.08749f
C7356 VIN.t531 VSS 0.00774f
C7357 VIN.n1346 VSS 0.08749f
C7358 VIN.t1417 VSS 0.00774f
C7359 VIN.n1347 VSS 0.08749f
C7360 VIN.t379 VSS 0.00774f
C7361 VIN.n1348 VSS 0.08749f
C7362 VIN.t1265 VSS 0.00774f
C7363 VIN.n1349 VSS 0.08749f
C7364 VIN.t525 VSS 0.00774f
C7365 VIN.n1350 VSS 0.08749f
C7366 VIN.t911 VSS 0.00774f
C7367 VIN.n1351 VSS 0.08749f
C7368 VIN.t348 VSS 0.00774f
C7369 VIN.n1352 VSS 0.08749f
C7370 VIN.t1251 VSS 0.00774f
C7371 VIN.n1353 VSS 0.08749f
C7372 VIN.t1625 VSS 0.00774f
C7373 VIN.n1354 VSS 0.08749f
C7374 VIN.t1087 VSS 0.00774f
C7375 VIN.n1355 VSS 0.08749f
C7376 VIN.t1379 VSS 0.00774f
C7377 VIN.n1356 VSS 0.08749f
C7378 VIN.t314 VSS 0.00774f
C7379 VIN.n1357 VSS 0.08749f
C7380 VIN.t1801 VSS 0.00774f
C7381 VIN.n1358 VSS 0.07176f
C7382 VIN.n1359 VSS 0.23783f
C7383 VIN.n1360 VSS 0.18423f
C7384 VIN.n1361 VSS 0.36816f
C7385 VIN.n1362 VSS 0.45213f
C7386 VIN.t1748 VSS 0.00879f
C7387 VIN.n1363 VSS 0.22953f
C7388 VIN.n1364 VSS 0.31649f
C7389 VIN.n1365 VSS 0.42986f
C7390 VIN.n1366 VSS 0.26099f
C7391 VIN.n1367 VSS 0.13036f
C7392 VIN.n1368 VSS 0.16887f
C7393 VIN.n1369 VSS 0.22606f
C7394 VIN.n1370 VSS 0.33909f
C7395 VIN.n1371 VSS 0.32295f
C7396 VIN.n1372 VSS 0.42986f
C7397 VIN.n1373 VSS 0.26099f
C7398 VIN.n1374 VSS 0.35524f
C7399 VIN.n1375 VSS 0.40368f
C7400 VIN.n1376 VSS 0.33775f
C7401 VIN.n1377 VSS 0.21493f
C7402 VIN.n1378 VSS 0.26099f
C7403 VIN.n1379 VSS 0.15179f
C7404 VIN.t1494 VSS 0.00879f
C7405 VIN.n1380 VSS 0.22953f
C7406 VIN.n1381 VSS 0.34878f
C7407 VIN.t1422 VSS 0.00879f
C7408 VIN.n1382 VSS 0.22953f
C7409 VIN.n1383 VSS 0.33586f
C7410 VIN.n1384 VSS 0.45213f
C7411 VIN.n1385 VSS 0.38381f
C7412 VIN.n1386 VSS 0.23783f
C7413 VIN.t1495 VSS 0.00774f
C7414 VIN.t1459 VSS 0.00774f
C7415 VIN.n1387 VSS 0.0729f
C7416 VIN.t2067 VSS 0.00774f
C7417 VIN.t2019 VSS 0.00774f
C7418 VIN.n1388 VSS 0.08863f
C7419 VIN.t1083 VSS 0.00774f
C7420 VIN.t1037 VSS 0.00774f
C7421 VIN.n1389 VSS 0.08863f
C7422 VIN.t787 VSS 0.00774f
C7423 VIN.t737 VSS 0.00774f
C7424 VIN.n1390 VSS 0.08863f
C7425 VIN.t1355 VSS 0.00774f
C7426 VIN.t1311 VSS 0.00774f
C7427 VIN.n1391 VSS 0.08863f
C7428 VIN.t959 VSS 0.00774f
C7429 VIN.t919 VSS 0.00774f
C7430 VIN.n1392 VSS 0.08863f
C7431 VIN.t2105 VSS 0.00774f
C7432 VIN.t2057 VSS 0.00774f
C7433 VIN.n1393 VSS 0.08863f
C7434 VIN.t621 VSS 0.00774f
C7435 VIN.t573 VSS 0.00774f
C7436 VIN.n1394 VSS 0.08863f
C7437 VIN.t205 VSS 0.00774f
C7438 VIN.t162 VSS 0.00774f
C7439 VIN.n1395 VSS 0.08863f
C7440 VIN.t987 VSS 0.00774f
C7441 VIN.t377 VSS 0.00774f
C7442 VIN.n1396 VSS 0.08863f
C7443 VIN.t32 VSS 0.00774f
C7444 VIN.t1511 VSS 0.00774f
C7445 VIN.n1397 VSS 0.08863f
C7446 VIN.t1145 VSS 0.00774f
C7447 VIN.t539 VSS 0.00774f
C7448 VIN.n1398 VSS 0.08863f
C7449 VIN.t218 VSS 0.00774f
C7450 VIN.t1665 VSS 0.00774f
C7451 VIN.n1399 VSS 0.08863f
C7452 VIN.t1405 VSS 0.00774f
C7453 VIN.t803 VSS 0.00774f
C7454 VIN.n1400 VSS 0.08863f
C7455 VIN.t420 VSS 0.00774f
C7456 VIN.t1833 VSS 0.00774f
C7457 VIN.n1401 VSS 0.08863f
C7458 VIN.t78 VSS 0.00774f
C7459 VIN.t1539 VSS 0.00774f
C7460 VIN.n1402 VSS 0.10181f
C7461 VIN.n1403 VSS 0.08361f
C7462 VIN.n1404 VSS 0.05349f
C7463 VIN.n1405 VSS 0.04698f
C7464 VIN.n1406 VSS 0.06795f
C7465 VIN.n1407 VSS 0.04265f
C7466 VIN.n1408 VSS 0.06557f
C7467 VIN.n1409 VSS 0.07112f
C7468 VIN.t346 VSS 0.00774f
C7469 VIN.n1410 VSS 0.10393f
C7470 VIN.t629 VSS 0.00774f
C7471 VIN.n1411 VSS 0.08806f
C7472 VIN.t1619 VSS 0.00774f
C7473 VIN.n1412 VSS 0.08806f
C7474 VIN.t477 VSS 0.00774f
C7475 VIN.n1413 VSS 0.08806f
C7476 VIN.t1377 VSS 0.00774f
C7477 VIN.n1414 VSS 0.08806f
C7478 VIN.t309 VSS 0.00774f
C7479 VIN.n1415 VSS 0.08806f
C7480 VIN.t1207 VSS 0.00774f
C7481 VIN.n1416 VSS 0.08806f
C7482 VIN.t11 VSS 0.00774f
C7483 VIN.n1417 VSS 0.08806f
C7484 VIN.t481 VSS 0.00774f
C7485 VIN.n1418 VSS 0.08806f
C7486 VIN.t1953 VSS 0.00774f
C7487 VIN.n1419 VSS 0.08806f
C7488 VIN.t815 VSS 0.00774f
C7489 VIN.n1420 VSS 0.08806f
C7490 VIN.t1209 VSS 0.00774f
C7491 VIN.n1421 VSS 0.08806f
C7492 VIN.t641 VSS 0.00774f
C7493 VIN.n1422 VSS 0.08806f
C7494 VIN.t943 VSS 0.00774f
C7495 VIN.n1423 VSS 0.08806f
C7496 VIN.t1933 VSS 0.00774f
C7497 VIN.n1424 VSS 0.08806f
C7498 VIN.t1389 VSS 0.00774f
C7499 VIN.n1425 VSS 0.07233f
C7500 VIN.n1426 VSS 0.22248f
C7501 VIN.n1427 VSS 0.04606f
C7502 VIN.n1428 VSS 0.22606f
C7503 VIN.n1429 VSS 0.43598f
C7504 VIN.t818 VSS 0.00879f
C7505 VIN.n1430 VSS 0.22953f
C7506 VIN.n1431 VSS 0.34232f
C7507 VIN.n1432 VSS 0.42986f
C7508 VIN.n1433 VSS 0.26099f
C7509 VIN.n1434 VSS 0.23783f
C7510 VIN.n1435 VSS 0.24564f
C7511 VIN.n1436 VSS 0.3068f
C7512 VIN.n1437 VSS 0.22606f
C7513 VIN.n1438 VSS 0.26805f
C7514 VIN.n1439 VSS 0.3531f
C7515 VIN.t503 VSS 0.00774f
C7516 VIN.t1059 VSS 0.00774f
C7517 VIN.t2097 VSS 0.00774f
C7518 VIN.t1789 VSS 0.00774f
C7519 VIN.t307 VSS 0.00774f
C7520 VIN.t1963 VSS 0.00774f
C7521 VIN.t1081 VSS 0.00774f
C7522 VIN.t1613 VSS 0.00774f
C7523 VIN.t1243 VSS 0.00774f
C7524 VIN.t609 VSS 0.00774f
C7525 VIN.t1755 VSS 0.00774f
C7526 VIN.t771 VSS 0.00774f
C7527 VIN.t1911 VSS 0.00774f
C7528 VIN.t1043 VSS 0.00774f
C7529 VIN.t2073 VSS 0.00774f
C7530 VIN.t1779 VSS 0.00774f
C7531 VIN.t1193 VSS 0.00774f
C7532 VIN.n1440 VSS 0.13439f
C7533 VIN.t1461 VSS 0.00774f
C7534 VIN.n1441 VSS 0.08693f
C7535 VIN.t449 VSS 0.00774f
C7536 VIN.n1442 VSS 0.08693f
C7537 VIN.t1319 VSS 0.00774f
C7538 VIN.n1443 VSS 0.08693f
C7539 VIN.t136 VSS 0.00774f
C7540 VIN.n1444 VSS 0.08693f
C7541 VIN.t1171 VSS 0.00774f
C7542 VIN.n1445 VSS 0.08693f
C7543 VIN.t2037 VSS 0.00774f
C7544 VIN.n1446 VSS 0.08693f
C7545 VIN.t1199 VSS 0.00774f
C7546 VIN.n1447 VSS 0.08693f
C7547 VIN.t1565 VSS 0.00774f
C7548 VIN.n1448 VSS 0.08693f
C7549 VIN.t1033 VSS 0.00774f
C7550 VIN.n1449 VSS 0.08693f
C7551 VIN.t1923 VSS 0.00774f
C7552 VIN.n1450 VSS 0.08693f
C7553 VIN.t255 VSS 0.00774f
C7554 VIN.n1451 VSS 0.08693f
C7555 VIN.t1739 VSS 0.00774f
C7556 VIN.n1452 VSS 0.08693f
C7557 VIN.t2043 VSS 0.00774f
C7558 VIN.n1453 VSS 0.08693f
C7559 VIN.t1007 VSS 0.00774f
C7560 VIN.n1454 VSS 0.08693f
C7561 VIN.t457 VSS 0.00774f
C7562 VIN.n1455 VSS 0.0712f
C7563 VIN.n1456 VSS 0.23783f
C7564 VIN.n1457 VSS 0.26099f
C7565 VIN.n1458 VSS 0.32941f
C7566 VIN.n1459 VSS 0.45213f
C7567 VIN.t1098 VSS 0.00879f
C7568 VIN.n1460 VSS 0.14879f
C7569 VIN.n1461 VSS 0.35524f
C7570 VIN.n1462 VSS 0.3531f
C7571 VIN.n1463 VSS 0.21493f
C7572 VIN.t1099 VSS 0.00774f
C7573 VIN.t1633 VSS 0.00774f
C7574 VIN.t643 VSS 0.00774f
C7575 VIN.t356 VSS 0.00774f
C7576 VIN.t921 VSS 0.00774f
C7577 VIN.t535 VSS 0.00774f
C7578 VIN.t1657 VSS 0.00774f
C7579 VIN.t168 VSS 0.00774f
C7580 VIN.t1827 VSS 0.00774f
C7581 VIN.t925 VSS 0.00774f
C7582 VIN.t2077 VSS 0.00774f
C7583 VIN.t1093 VSS 0.00774f
C7584 VIN.t170 VSS 0.00774f
C7585 VIN.t1357 VSS 0.00774f
C7586 VIN.t352 VSS 0.00774f
C7587 VIN.t2109 VSS 0.00774f
C7588 VIN.t679 VSS 0.00774f
C7589 VIN.n1464 VSS 0.10124f
C7590 VIN.t975 VSS 0.00774f
C7591 VIN.n1465 VSS 0.08806f
C7592 VIN.t1959 VSS 0.00774f
C7593 VIN.n1466 VSS 0.08806f
C7594 VIN.t801 VSS 0.00774f
C7595 VIN.n1467 VSS 0.08806f
C7596 VIN.t1687 VSS 0.00774f
C7597 VIN.n1468 VSS 0.08806f
C7598 VIN.t655 VSS 0.00774f
C7599 VIN.n1469 VSS 0.08806f
C7600 VIN.t1517 VSS 0.00774f
C7601 VIN.n1470 VSS 0.08806f
C7602 VIN.t1061 VSS 0.00774f
C7603 VIN.n1471 VSS 0.08806f
C7604 VIN.t1435 VSS 0.00774f
C7605 VIN.n1472 VSS 0.08806f
C7606 VIN.t885 VSS 0.00774f
C7607 VIN.n1473 VSS 0.08806f
C7608 VIN.t1767 VSS 0.00774f
C7609 VIN.n1474 VSS 0.08806f
C7610 VIN.t76 VSS 0.00774f
C7611 VIN.n1475 VSS 0.08806f
C7612 VIN.t1599 VSS 0.00774f
C7613 VIN.n1476 VSS 0.08806f
C7614 VIN.t1895 VSS 0.00774f
C7615 VIN.n1477 VSS 0.08806f
C7616 VIN.t847 VSS 0.00774f
C7617 VIN.n1478 VSS 0.08806f
C7618 VIN.t283 VSS 0.00774f
C7619 VIN.n1479 VSS 0.07233f
C7620 VIN.n1480 VSS 0.23783f
C7621 VIN.n1481 VSS 0.15352f
C7622 VIN.n1482 VSS 0.3068f
C7623 VIN.n1483 VSS 0.45213f
C7624 VIN.n1484 VSS 0.3617f
C7625 VIN.n1485 VSS 0.42986f
C7626 VIN.n1486 VSS 0.29169f
C7627 VIN.n1487 VSS 0.30034f
C7628 VIN.n1488 VSS 0.22606f
C7629 VIN.n1489 VSS 0.13817f
C7630 VIN.n1490 VSS 0.23028f
C7631 VIN.n1491 VSS 0.42986f
C7632 VIN.n1492 VSS 0.36816f
C7633 VIN.t113 VSS 0.00879f
C7634 VIN.n1493 VSS 0.22953f
C7635 VIN.n1494 VSS 0.31003f
C7636 VIN.n1495 VSS 0.14855f
C7637 VIN.n1496 VSS 0.27451f
C7638 VIN.n1497 VSS 0.45213f
C7639 VIN.n1498 VSS 0.3531f
C7640 VIN.n1499 VSS 0.23783f
C7641 VIN.t114 VSS 0.00774f
C7642 VIN.t50 VSS 0.00774f
C7643 VIN.n1500 VSS 0.07233f
C7644 VIN.t705 VSS 0.00774f
C7645 VIN.t663 VSS 0.00774f
C7646 VIN.n1501 VSS 0.08806f
C7647 VIN.t1741 VSS 0.00774f
C7648 VIN.t1699 VSS 0.00774f
C7649 VIN.n1502 VSS 0.08806f
C7650 VIN.t1453 VSS 0.00774f
C7651 VIN.t1415 VSS 0.00774f
C7652 VIN.n1503 VSS 0.08806f
C7653 VIN.t2015 VSS 0.00774f
C7654 VIN.t1971 VSS 0.00774f
C7655 VIN.n1504 VSS 0.08806f
C7656 VIN.t1623 VSS 0.00774f
C7657 VIN.t1573 VSS 0.00774f
C7658 VIN.n1505 VSS 0.08806f
C7659 VIN.t735 VSS 0.00774f
C7660 VIN.t681 VSS 0.00774f
C7661 VIN.n1506 VSS 0.08806f
C7662 VIN.t1309 VSS 0.00774f
C7663 VIN.t1255 VSS 0.00774f
C7664 VIN.n1507 VSS 0.08806f
C7665 VIN.t909 VSS 0.00774f
C7666 VIN.t855 VSS 0.00774f
C7667 VIN.n1508 VSS 0.08806f
C7668 VIN.t1747 VSS 0.00774f
C7669 VIN.t1161 VSS 0.00774f
C7670 VIN.n1509 VSS 0.08806f
C7671 VIN.t881 VSS 0.00774f
C7672 VIN.t259 VSS 0.00774f
C7673 VIN.n1510 VSS 0.08806f
C7674 VIN.t1921 VSS 0.00774f
C7675 VIN.t1329 VSS 0.00774f
C7676 VIN.n1511 VSS 0.08806f
C7677 VIN.t1031 VSS 0.00774f
C7678 VIN.t437 VSS 0.00774f
C7679 VIN.n1512 VSS 0.08806f
C7680 VIN.t109 VSS 0.00774f
C7681 VIN.t1569 VSS 0.00774f
C7682 VIN.n1513 VSS 0.08806f
C7683 VIN.t1201 VSS 0.00774f
C7684 VIN.t591 VSS 0.00774f
C7685 VIN.n1514 VSS 0.08806f
C7686 VIN.t915 VSS 0.00774f
C7687 VIN.t287 VSS 0.00774f
C7688 VIN.n1515 VSS 0.10124f
C7689 VIN.n1516 VSS 0.08361f
C7690 VIN.t2119 VSS 0.00692f
C7691 VIN.t2127 VSS 0.00692f
C7692 VIN.n1517 VSS 0.01918f
C7693 VIN.n1518 VSS 0.04698f
C7694 VIN.n1519 VSS 0.04481f
C7695 VIN.n1520 VSS 0.03542f
C7696 VIN.n1521 VSS 0.06636f
C7697 VIN.n1522 VSS 0.02819f
C7698 VIN.n1523 VSS 0.02544f
C7699 VIN.n1524 VSS 0.05204f
C7700 VIN.n1525 VSS 0.04192f
C7701 VIN.n1526 VSS 0.04265f
C7702 VIN.n1527 VSS 0.04265f
C7703 VIN.n1528 VSS 0.05638f
C7704 VIN.n1529 VSS 0.03614f
C7705 VIN.n1530 VSS 0.04467f
C7706 VIN.n1531 VSS 0.057f
C7707 VIN.n1532 VSS 0.02862f
C7708 VIN.n1533 VSS 0.05556f
C7709 VIN.n1534 VSS 0.60303f
C7710 VIN.n1535 VSS 0.08145f
C7711 VIN.n1536 VSS 0.13048f
C7712 VIN.n1537 VSS 0.17097f
C7713 VIN.n1538 VSS 0.18024f
C7714 VIN.n1539 VSS 0.08145f
C7715 VIN.n1540 VSS 0.60303f
C7716 VIN.n1541 VSS 0.05556f
C7717 VIN.n1542 VSS 0.03975f
C7718 VIN.n1543 VSS 0.06557f
C7719 VIN.n1544 VSS 0.04265f
C7720 VIN.n1545 VSS 0.0477f
C7721 VIN.n1546 VSS 0.08361f
C7722 VIN.t1593 VSS 0.00774f
C7723 VIN.n1547 VSS 0.10068f
C7724 VIN.t1885 VSS 0.00774f
C7725 VIN.n1548 VSS 0.08749f
C7726 VIN.t843 VSS 0.00774f
C7727 VIN.n1549 VSS 0.08749f
C7728 VIN.t1711 VSS 0.00774f
C7729 VIN.n1550 VSS 0.08749f
C7730 VIN.t577 VSS 0.00774f
C7731 VIN.n1551 VSS 0.08749f
C7732 VIN.t1553 VSS 0.00774f
C7733 VIN.n1552 VSS 0.08749f
C7734 VIN.t414 VSS 0.00774f
C7735 VIN.n1553 VSS 0.08749f
C7736 VIN.t1903 VSS 0.00774f
C7737 VIN.n1554 VSS 0.08749f
C7738 VIN.t234 VSS 0.00774f
C7739 VIN.n1555 VSS 0.08749f
C7740 VIN.t1729 VSS 0.00774f
C7741 VIN.n1556 VSS 0.08749f
C7742 VIN.t593 VSS 0.00774f
C7743 VIN.n1557 VSS 0.08749f
C7744 VIN.t991 VSS 0.00774f
C7745 VIN.n1558 VSS 0.08749f
C7746 VIN.t447 VSS 0.00774f
C7747 VIN.n1559 VSS 0.08749f
C7748 VIN.t711 VSS 0.00774f
C7749 VIN.n1560 VSS 0.08749f
C7750 VIN.t1701 VSS 0.00774f
C7751 VIN.n1561 VSS 0.08749f
C7752 VIN.t1165 VSS 0.00774f
C7753 VIN.n1562 VSS 0.07176f
C7754 VIN.n1563 VSS 0.23783f
C7755 VIN.n1564 VSS 0.24564f
C7756 VIN.n1565 VSS 0.30357f
C7757 VIN.n1566 VSS 0.45213f
C7758 VIN.t1784 VSS 0.00879f
C7759 VIN.n1567 VSS 0.22953f
C7760 VIN.n1568 VSS 0.38108f
C7761 VIN.n1569 VSS 0.42986f
C7762 VIN.n1570 VSS 0.3224f
C7763 VIN.n1571 VSS 0.23783f
C7764 VIN.n1572 VSS 0.22606f
C7765 VIN.n1573 VSS 0.33909f
C7766 VIN.t960 VSS 0.00879f
C7767 VIN.n1574 VSS 0.22953f
C7768 VIN.n1575 VSS 0.38754f
C7769 VIN.n1576 VSS 0.42986f
C7770 VIN.n1577 VSS 0.3224f
C7771 VIN.n1578 VSS 0.23783f
C7772 VIN.n1579 VSS 0.27634f
C7773 VIN.n1580 VSS 0.40368f
C7774 VIN.n1581 VSS 0.22606f
C7775 VIN.n1582 VSS 0.21637f
C7776 VIN.n1583 VSS 0.26099f
C7777 VIN.n1584 VSS 0.3224f
C7778 VIN.n1585 VSS 0.55202f
.ends
