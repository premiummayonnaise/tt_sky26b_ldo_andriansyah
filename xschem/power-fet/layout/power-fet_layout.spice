* NGSPICE file created from power-fet.ext - technology: sky130A

.subckt sky130_fd_pr__pfet_01v8_E8WXEL a_n298_786# a_3465_1249# a_n2683_n313# a_n6446_n2220#
+ a_n510_n1218# a_6433_n2651# a_n5272_n1552# a_n3107_1583# a_5373_n1757# a_1512_118#
+ a_2829_1023# a_n1994_n1886# a_n3266_786# a_n5696_n1218# a_n6022_n2220# a_n722_786#
+ a_n3743_n2651# a_4578_n1552# a_n2683_n1757# a_497_n2091# a_n396_n2220# a_5850_452#
+ a_n1994_452# a_n1570_n1886# a_5328_n2220# a_n5272_n1218# a_974_n2220# a_n4848_452#
+ a_n4636_n550# a_n139_n1649# a_4154_n1552# a_4313_1357# a_n3531_n421# a_n2728_2456#
+ a_4578_n1218# a_n2304_452# a_6176_n2554# a_n6446_2456# a_550_n2220# a_1724_786#
+ a_n2471_1249# a_n3478_1788# a_5850_118# a_n1994_118# a_n2895_581# a_n4114_n550#
+ a_6600_n884# a_n6544_n1552# a_3253_1023# a_n722_n550# a_6645_n1757# a_n4848_118#
+ a_n4636_n216# a_n5227_2359# a_n6120_n884# a_4154_n1218# a_n4636_1120# a_664_n884#
+ a_6009_1917# a_n1668_2122# a_n2206_2456# a_n1835_1023# a_n5060_786# a_n5386_2122#
+ a_n2304_118# a_n3955_n1757# a_1822_n550# a_n6120_n1552# a_6221_n1757# a_5540_n550#
+ a_3094_786# a_n4114_n216# a_n2842_n1886# a_n4167_2025# a_4737_2585# a_n4114_1120#
+ a_6486_1788# a_n1570_2456# a_n5060_n550# a_n6544_n1218# a_6600_1454# a_n1199_1357#
+ a_n1146_2122# a_n722_n216# a_1769_n1315# a_n6022_452# a_n775_2025# a_3632_2456#
+ a_n3743_21# a_n722_1120# a_5426_n1552# a_n3531_n1757# a_6698_n1886# a_4480_n2220#
+ a_3208_2122# a_664_1454# a_n6120_1454# a_n3152_2456# a_1186_n884# a_2193_n1983#
+ a_1300_n550# a_5214_2456# a_921_2585# a_4056_452# a_2246_1788# a_1822_n216# a_n6120_n1218#
+ a_1822_1120# a_1345_n1315# a_3677_2251# a_5540_n216# a_5002_n1552# a_1769_21# a_73_21#
+ a_6274_n1886# a_5540_1120# a_2572_2122# a_n5060_n216# a_1724_n1886# a_n2516_786#
+ a_n5060_1120# a_n6022_118# a_5426_n1218# a_n2092_2122# a_4101_n313# a_n2259_n1089#
+ a_4154_2122# a_1088_n1552# a_1300_n216# a_1186_1454# a_1300_1120# a_n5015_1917#
+ a_709_n2317# a_4056_118# a_n6287_n647# a_28_2122# a_1300_n1886# a_6009_21# a_3889_n1983#
+ a_n1456_n2220# a_5161_2585# a_5002_n1218# a_n987_n1649# a_1557_n2425# a_5797_1691#
+ a_550_786# a_n3743_2585# a_n3478_n1552# a_n4803_n1757# a_5752_n2220# a_n2047_n647#
+ a_1088_n1218# a_3465_n1983# a_n1032_n2220# a_1133_n2425# a_1345_21# a_n4167_n1423#
+ a_n563_n1649# a_1557_1691# a_n6234_786# a_n6658_n884# a_2617_n1315# a_n3054_n1552#
+ a_28_n2220# a_n2683_2251# a_3041_n1983# a_n6711_1249# a_n3478_n1218# a_4268_786#
+ a_n4962_452# a_1769_n87# a_n2418_n884# a_n6499_n2317# a_3465_581# a_n5908_2122#
+ a_n5598_n550# a_n1199_n87# a_1186_n2554# a_2996_452# a_n2728_n2220# a_n3054_n1218#
+ a_2829_n2425# a_n6658_1454# a_n351_581# a_73_n755# a_n608_n884# a_n3107_n1089# a_n6075_n2317#
+ a_n6075_n421# a_6645_n981# a_n1782_n884# a_n1358_n550# a_n4962_118# a_n5863_581#
+ a_n5810_2456# a_3844_n884# a_n5439_1357# a_n86_n884# a_n2842_1788# a_5797_n1089#
+ a_4737_n1983# a_n3576_n2554# a_n2304_n2220# a_3306_452# a_n2418_1454# a_n3364_n884#
+ a_5850_n1552# a_2405_n2425# a_4904_1788# a_n5598_n216# a_n5439_n1423# a_497_581#
+ a_n1623_n87# a_n5598_1120# a_5426_n884# a_2996_118# a_n4424_1788# a_2405_n981# a_n4326_n1552#
+ a_n5598_n1886# a_6600_n2220# a_n608_1454# a_5373_n1089# a_4313_n1983# a_2784_n550#
+ a_126_n1886# a_n3152_n2554# a_4949_1583# a_n4750_2122# a_n5015_n1423# a_n4379_1023#
+ a_n1782_1454# a_6698_2456# a_n1358_n216# a_6062_786# a_n1358_1120# a_n987_1023#
+ a_3844_1454# a_4790_n884# a_3306_118# a_n86_1454# a_4366_n550# a_5850_n1218# a_876_2122#
+ a_n6332_2122# a_n5174_n1886# a_921_581# a_n3364_1454# a_n2683_n1089# a_n1623_n1983#
+ a_338_452# a_2458_n2554# a_5850_1788# a_5426_1454# a_n510_1788# a_n139_2359# a_2458_2456#
+ a_n4326_n1218# a_4790_452# a_6176_2456# a_3208_n1552# a_n298_2122# a_550_n550# a_n1880_n2220#
+ a_2784_n216# a_1981_n2425# a_n3788_452# a_2784_1120# a_n298_n2554# a_n2630_786#
+ a_2034_n2554# a_1610_1788# a_n5651_n981# a_4790_1454# a_4366_n216# a_876_n2554#
+ a_n4848_n2554# a_338_118# a_n1244_452# a_4366_1120# a_1398_2122# a_4056_n1886# a_n4591_n1423#
+ a_4790_118# a_n1411_n981# a_3518_786# a_3208_n1218# a_5373_1583# a_550_n216# a_6645_n1089#
+ a_n4424_n2554# a_n3788_118# a_550_1120# a_452_n2554# a_6009_1249# a_n3955_1583#
+ a_n5227_n313# a_n6446_n1886# a_n3955_n1089# a_n1244_118# a_4101_2251# a_1133_1583#
+ a_6221_n1089# a_2784_n1552# a_n4000_n2554# a_2829_2359# a_n6287_2585# a_n6022_n1886#
+ a_n3531_n1089# a_2360_n1552# a_3306_n2554# a_n396_n1886# a_n2047_2585# a_2784_n1218#
+ a_5328_n1886# a_n5439_21# a_6221_1691# a_1769_2025# a_4737_n87# a_974_n1886# a_n5863_n1423#
+ a_6433_581# a_285_1691# a_n4803_1691# a_n4167_n87# a_5964_452# a_n1456_786# a_n4750_n1552#
+ a_n4962_n550# a_2360_n1218# a_709_n981# a_550_n1886# a_1557_355# a_n987_355# a_n5015_1249#
+ a_3420_452# a_n6544_n550# a_3253_2359# a_n2418_452# a_5373_915# a_1610_n2220# a_2882_n2554#
+ a_n86_452# a_n4636_2456# a_5964_118# a_n1668_1788# a_n1835_2359# a_6388_n884# a_n4750_n1218#
+ a_n5386_1788# a_n4962_n216# a_n2304_n550# a_n4803_n1089# a_n3955_355# a_2617_1917#
+ a_3632_n1552# a_n1358_n2554# a_n5015_21# a_n4962_1120# a_n1994_2122# a_3889_n647#
+ a_n6022_n550# a_3420_118# a_n6544_n216# a_2193_2025# a_n5174_786# a_n6544_1120#
+ a_452_452# a_n1411_355# a_n3576_2122# a_n4114_2456# a_2148_n884# a_n2418_118# a_n3319_581#
+ a_n1146_1788# a_n86_118# a_5638_2122# a_n722_2456# a_4480_n1886# a_3208_1788# a_3730_n550#
+ a_6388_1454# a_n2304_n216# a_3632_n1218# a_n2304_1120# a_n6022_n216# a_n6711_n1423#
+ a_n6022_1120# a_1822_2456# a_n6756_452# a_1088_n550# a_n4379_n1649# a_2829_915#
+ a_n3054_2122# a_5540_2456# a_452_118# a_5116_2122# a_2572_1788# a_2148_1454# a_n5863_1917#
+ a_n5060_2456# a_3094_n884# a_n2259_915# a_n2092_1788# a_n4212_452# a_1769_689# a_4737_n755#
+ a_3632_786# a_4154_1788# a_3730_n216# a_3730_1120# a_3041_1917# a_1300_2456# a_n1199_689#
+ a_4904_n1552# a_4480_2122# a_n722_n2220# a_n6756_118# a_2246_452# a_28_1788# a_n1623_1917#
+ a_1088_n216# a_n1456_n1886# a_3730_n2554# a_1088_1120# a_n2895_n647# a_921_n755#
+ a_n86_n1552# a_6062_2122# a_n2206_n2554# a_3094_n2220# a_3094_1454# a_3677_n421#
+ a_n4212_118# a_n563_n981# a_5752_n1886# a_n1032_n1886# a_n6499_1583# a_664_786#
+ a_n1623_689# a_4904_n1218# a_2246_118# a_28_n1886# a_n5484_n2220# a_n5227_2251#
+ a_n86_n1218# a_n2259_1583# a_5161_n755# a_n139_n313# a_n4848_n884# a_n5227_n1649#
+ a_n1570_786# a_n3743_n755# a_n5060_n2220# a_n5908_1788# a_n4424_786# a_n2728_n1886#
+ a_n1782_n2554# a_n6499_355# a_n820_n1552# a_4525_355# a_n4326_n884# a_4366_n2220#
+ a_6433_2025# a_n3788_n550# a_n1199_n2091# a_2458_786# a_3465_1357# a_n934_n884#
+ a_n2683_n421# a_n4848_1454# a_497_2025# a_n2304_n1886# a_6388_n1552# a_n5598_2456#
+ a_n3107_1691# a_6600_n1886# a_n3690_n884# a_n3266_n550# a_n820_n1218# a_n6756_n2220#
+ a_5752_n884# a_5328_n550# a_n4750_1788# a_n3788_n216# a_n4326_1454# a_n4379_2359#
+ a_497_n1983# a_n3788_1120# a_n5272_n884# a_n1358_2456# a_n987_2359# a_n934_1454#
+ a_2829_n313# a_876_1788# a_n6332_1788# a_6388_n1218# a_n6332_n2220# a_1512_n884#
+ a_n2940_2122# a_6176_786# a_4692_n550# a_n1032_n884# a_n139_n1757# a_n3266_n216#
+ a_n3690_1454# a_3889_2585# a_n3266_1120# a_5752_1454# a_n298_1788# a_5328_n216#
+ a_n1880_n1886# a_5638_n2220# a_5328_1120# a_2784_2456# a_6274_n550# a_n5272_1454#
+ a_n2471_1357# a_n2630_n2554# a_n5227_915# a_4313_n647# a_4366_2456# a_1398_1788#
+ a_4737_689# a_6600_786# a_1512_1454# a_6486_n2554# a_5214_n2220# a_4692_n216# a_2034_n550#
+ a_73_n1315# a_n2047_n2091# a_2360_452# a_n4000_2122# a_4692_1120# a_n1032_1454#
+ a_n4167_689# a_1936_n2554# a_5373_247# a_5214_452# a_n1358_452# a_550_2456# a_6274_n216#
+ a_126_2122# a_6274_1120# a_1981_1583# a_3253_n313# a_6062_n2554# a_n775_n2651# a_2617_1249#
+ a_n4167_1917# a_n1835_n313# a_1512_n2554# a_n5651_n1649# a_n775_1917# a_1769_n1423#
+ a_2360_118# a_2034_n216# a_2034_1120# a_n351_n2651# a_5214_118# a_n1358_118# a_n2895_2585#
+ a_n1199_n647# a_6009_n2091# a_1345_n1423# a_4790_n2220# a_n184_452# a_n3902_n2554#
+ a_n3266_n2220# a_n2047_21# a_2829_247# a_n5696_452# a_n3319_n2091# a_4101_n421#
+ a_n2092_n1552# a_n5863_1249# a_n2259_247# a_709_n2425# a_n3152_452# a_3677_n2317#
+ a_6645_1023# a_n6287_n755# a_2572_786# a_3041_1249# a_n184_118# a_1398_n1552# a_n987_n1757#
+ a_n139_2251# a_5426_786# a_n1623_1249# a_n5696_118# a_1186_452# a_1610_n1886# a_2148_n2220#
+ a_3253_n2317# a_5585_n2091# a_2405_1023# a_n2047_n755# a_n6287_n1315# a_n2092_n1218#
+ a_n563_n1757# a_5797_n981# a_n3152_118# a_n4962_2456# a_2996_n884# a_n4538_2122#
+ a_n3788_n1552# a_n1994_1788# a_2617_n1423# a_n2895_n2091# a_1398_n1218# a_n2630_n550#
+ a_5161_n2091# a_1610_452# a_n6544_2456# a_4578_n884# a_1186_118# a_n6711_1357# a_n4538_n2220#
+ a_n3576_1788# a_1557_n981# a_n3319_2025# a_5638_1788# a_n4212_n550# a_n396_786#
+ a_n3364_n1552# a_338_n2554# a_n820_n550# a_n6499_n2425# a_n2471_n2091# a_5964_2122#
+ a_762_n884# a_4949_n2317# a_n2304_2456# a_338_n550# a_n4114_n2220# a_2996_1454#
+ a_n3788_n1218# a_n5386_n2554# a_n6022_2456# a_4056_n884# a_n5484_2122# a_n5651_1023#
+ a_n3054_1788# a_n2630_n216# a_1610_118# a_n2630_1120# a_2829_2251# a_n6075_n2425#
+ a_4578_1454# a_5116_1788# a_n3364_786# a_n184_n884# a_n820_786# a_1724_2122# a_n4212_n216#
+ a_4525_n2317# a_n3364_n1218# a_n4212_1120# a_240_n884# a_n1244_2122# a_n820_n216#
+ a_n1411_1023# a_2246_n1552# a_n820_1120# a_3730_2456# a_1398_786# a_3306_2122# a_338_n216#
+ a_762_1454# a_338_1120# a_921_n1315# a_4480_1788# a_n722_n1886# a_n1835_n2317# a_n4326_452#
+ a_4056_1454# a_4101_n2317# a_n5439_n647# a_4268_n2554# a_6433_n2091# a_1088_2456#
+ a_4313_2585# a_6062_1788# a_4949_1691# a_3094_n1886# a_n184_1454# a_n351_2025# a_2670_2122#
+ a_n4636_n1552# a_n3690_n2220# a_664_n1552# a_n1411_n2317# a_240_1454# a_n3743_n2091#
+ a_1822_786# a_2246_n1218# a_n6658_n2554# a_n4379_n313# a_n4326_118# a_n987_n313#
+ a_2996_n2220# a_3253_2251# a_n4212_n1552# a_240_n1552# a_n5484_n1886# a_n139_n1089#
+ a_n1835_2251# a_n4636_n1218# a_664_n1218# a_n6234_n2554# a_2572_n2220# a_3518_n1552#
+ a_n5060_n1886# a_n5227_247# a_709_1023# a_n775_21# a_6698_452# a_n6120_452# a_n1199_2585#
+ a_n4212_n1218# a_240_n1218# a_5540_786# a_5373_1691# a_n6756_n884# a_4366_n1886#
+ a_6009_1357# a_n5908_n1552# a_n184_n2554# a_n4962_n2220# a_n4538_786# a_n3955_1691#
+ a_n5227_n421# a_4154_452# a_3518_n1218# a_5116_n2554# a_n2471_n87# a_762_n2554#
+ a_1133_1691# a_n2516_n884# a_n608_452# a_n4167_1249# a_n6120_118# a_n5696_n550#
+ a_n6234_n884# a_6698_118# a_n775_1249# a_n6756_n1886# a_1769_581# a_n6756_1454#
+ a_n3788_2456# a_n3902_2122# a_1936_n550# a_n5908_n1218# a_4154_118# a_n1199_581#
+ a_n1880_n884# a_3844_n2220# a_n351_21# a_1769_1917# a_n1456_n550# a_3942_n884# a_n6332_n1886#
+ a_n608_n2220# a_n5174_n550# a_3518_n550# a_n2940_1788# a_2670_n1552# a_n608_118#
+ a_n2516_1454# a_n5696_n216# a_n5696_1120# a_n6234_1454# a_n3266_2456# a_n1146_n1552#
+ a_3420_n2220# a_5638_n1886# a_4692_n2554# a_5328_2456# a_1936_n216# a_6221_n981#
+ a_n1623_581# a_n4167_n2651# a_1936_1120# a_2882_n550# a_3420_n884# a_n6332_786#
+ a_n5015_1357# a_285_n981# a_n1456_n216# a_n2092_452# a_n1880_1454# a_n4803_n981#
+ a_n1456_1120# a_3518_n216# a_3942_1454# a_n5174_n216# a_1557_n1649# a_3518_1120#
+ a_n5174_1120# a_5002_n884# a_n987_n1089# a_2670_n1218# a_5214_n1886# a_974_2122#
+ a_n4000_1788# a_4366_786# a_4692_2456# a_n5810_n2220# a_4268_2122# a_n1146_n1218#
+ a_2360_n550# a_126_1788# a_4525_1583# a_6274_2456# a_1133_n1649# a_3889_n755# a_n396_2122#
+ a_2882_n216# a_n563_n1089# a_n563_1023# a_3420_1454# a_2193_1917# a_n2092_118# a_2882_1120#
+ a_452_2122# a_5328_452# a_n1668_n2554# a_3942_n1552# a_5002_1454# a_2034_2456# a_n2418_n1552#
+ a_5964_n2554# a_n5439_2585# a_2360_n216# a_6433_21# a_2360_1120# a_n1244_n2554#
+ a_n5439_n2651# a_n4379_n1757# a_4790_n1886# a_5328_118# a_5585_n87# a_2829_n1649#
+ a_3942_n1218# a_n3266_n1886# a_5540_n2554# a_n298_452# a_n4379_2251# a_n5015_n2651#
+ a_n2418_n1218# a_n987_2251# a_3041_n87# a_2405_n1649# a_6645_2359# a_n3531_1583#
+ a_n2895_n755# a_n1994_n1552# a_n3266_452# a_n722_452# a_2148_n1886# a_n298_118#
+ a_2405_2359# a_n6499_1691# a_n3478_n884# a_5585_2025# a_n1570_n1552# a_n2516_n2554#
+ a_n4538_1788# a_4737_581# a_n4591_n2651# a_n1994_n1218# a_n3266_118# a_n4167_581#
+ a_n2259_1691# a_1345_2025# a_n4538_n1886# a_n722_118# a_n2728_2122# a_n139_n421#
+ a_1981_n1649# a_n5227_n1757# a_6176_n2220# a_n6446_2122# a_1724_452# a_n3478_1454#
+ a_5964_1788# a_6486_n884# a_n1570_n1218# a_n4114_n1886# a_3677_915# a_6600_n550#
+ a_n5484_1788# a_n5651_2359# a_n2630_2456# a_n6120_n550# a_664_n550# a_6433_1917#
+ a_n2206_2122# a_n1199_n1983# a_n5060_452# a_n563_915# a_1724_1788# a_1133_915# a_497_1917#
+ a_4480_786# a_n4212_2456# a_2246_n884# a_n1244_1788# a_n1411_2359# a_1724_118# a_n820_2456#
+ a_3306_1788# a_n3478_786# a_3094_452# a_n4591_2025# a_338_2456# a_n2842_n1552# a_n934_786#
+ a_6600_n216# a_6486_1454# a_n1570_2122# a_3465_n647# a_6600_1120# a_n5863_n2651#
+ a_3632_2122# a_n6120_n216# a_664_n216# a_6698_n1552# a_285_n2317# a_n3531_915# a_n6120_1120#
+ a_664_1120# a_1186_n550# a_n5060_118# a_n3152_2122# a_5214_2122# a_n3107_n981# a_n3690_n1886#
+ a_2670_1788# a_2829_n421# a_2246_1454# a_n2471_689# a_n3902_786# a_6274_n1552# a_3094_118#
+ a_n2842_n1218# a_1769_1249# a_1724_n1552# a_n2516_452# a_2996_n1886# a_6698_n1218#
+ a_1936_786# a_1186_n216# a_2193_n1315# a_1186_1120# a_4313_n755# a_1300_n1552# a_2572_n1886#
+ a_6274_n1218# a_n2047_n1983# a_550_452# a_n5272_786# a_709_2359# a_73_n1423# a_1724_n1218#
+ a_n2516_118# a_n2940_n2554# a_n2471_n647# a_5373_355# a_1981_1691# a_3253_n421#
+ a_n4962_n1886# a_n6234_452# a_2617_1357# a_1300_n1218# a_n5863_21# a_n6658_n550#
+ a_3889_n1315# a_n6711_n2651# a_n6075_1583# a_n1835_n421# a_n5651_n1757# a_5797_1023#
+ a_2193_1249# a_550_118# a_4268_452# a_n2842_n884# a_1822_n2554# a_3889_21# a_3730_786#
+ a_n2418_n550# a_3465_n1315# a_6009_n1983# a_4904_n884# a_1557_1023# a_n1199_n755#
+ a_n3902_1788# a_n5439_n87# a_1186_n2220# a_n4424_n884# a_n6234_118# a_n2728_786#
+ a_3844_n1886# a_n6658_n216# a_n6658_1120# a_n608_n550# a_n608_n1886# a_n4379_n1089#
+ a_n3319_n1983# a_2829_355# a_3041_n1315# a_n1782_n550# a_4268_118# a_n5696_2456#
+ a_3844_n550# a_n2259_355# a_n5863_1357# a_n5810_2122# a_6645_915# a_n2418_n216#
+ a_n86_n550# a_3420_n1886# a_n2842_1454# a_n3576_n2220# a_n2418_1120# a_n3364_n550#
+ a_3677_n2425# a_762_786# a_4904_1454# a_5850_n884# a_3041_1357# a_1936_2456# a_5426_n550#
+ a_n510_n884# a_n6075_915# a_n4424_1454# a_5585_689# a_4101_915# a_n1456_2456# a_n5598_n1552#
+ a_n1623_1357# a_n608_n216# a_3518_2456# a_3465_21# a_n608_1120# a_n5174_2456# a_5585_n1983#
+ a_n3152_n2220# a_974_1788# a_6645_n313# a_n1782_n216# a_126_n1552# a_3253_n2425#
+ a_n6287_n1423# a_n6446_786# a_n1782_1120# a_6698_2122# a_1610_n884# a_n5810_n1886#
+ a_6062_452# a_4268_1788# a_3844_n216# a_3041_689# a_n86_n216# a_3844_1120# a_4790_n550#
+ a_4737_n1315# a_n86_1120# a_n3364_n216# a_n5174_n1552# a_n3364_1120# a_n2895_n1983#
+ a_5850_1454# a_n396_1788# a_5426_n216# a_2458_n2220# a_n510_1454# a_n563_2359# a_5161_n1983#
+ a_5426_1120# a_2882_2456# a_2405_n313# a_2458_2122# a_n5598_n1218# a_452_1788# a_n934_n2554#
+ a_n3319_1917# a_6176_2122# a_4313_n1315# a_126_n1218# a_n2471_n1983# a_n298_n2220#
+ a_n2630_452# a_2034_n2220# a_6062_118# a_1610_1454# a_3465_2585# a_4790_n216# a_n4848_n2220#
+ a_4790_1120# a_n6711_n647# a_n5174_n1218# a_4949_n2425# a_876_n2220# a_2360_2456#
+ a_n1623_n1315# a_n510_n2554# a_n5227_n1089# a_3041_21# a_4904_786# a_4056_n1552#
+ a_3677_247# a_3518_452# a_n5696_n2554# a_452_n2220# a_n4424_n2220# a_4525_n2425#
+ a_n2630_118# a_6433_1249# a_n5651_n313# a_1133_247# a_n563_247# a_497_1249# a_n6446_n1552#
+ a_4056_n1218# a_921_n1423# a_n1835_n2425# a_6433_n1983# a_n4000_n2220# a_n5272_n2554#
+ a_4101_n2425# a_n5439_n755# a_6274_786# a_n1411_n313# a_3518_118# a_n351_1917# a_n6022_n1552#
+ a_6009_n87# a_n3531_247# a_n3743_n1983# a_3306_n2220# a_4578_n2554# a_n1411_n2425#
+ a_n6446_n1218# a_n396_n1552# a_n2471_2585# a_n4379_n421# a_4949_n981# a_5328_n1552#
+ a_n2842_786# a_n987_n421# a_974_n1552# a_4154_n2554# a_n1668_n884# a_n6022_n1218#
+ a_n1456_452# a_n5386_n884# a_n2728_1788# a_6176_n1886# a_n6446_1788# a_550_n1552#
+ a_n396_n1218# a_5328_n1218# a_n5227_355# a_6221_1023# a_n1146_n884# a_974_n1218#
+ a_n6544_n2554# a_1769_n2651# a_285_1023# a_3208_n884# a_2882_n2220# a_n4636_2122#
+ a_n4803_1023# a_n1668_1454# a_n2206_1788# a_6388_n550# a_n1456_118# a_n5386_1454#
+ a_n1358_n2220# a_709_n313# a_n6120_n2554# a_550_n1218# a_1345_n2651# a_5373_n981#
+ a_n775_n2091# a_2572_n884# a_n5174_452# a_73_n87# a_2148_n550# a_n4167_1357# a_n1570_1788#
+ a_n4114_2122# a_6009_n647# a_6600_2456# a_n3955_n981# a_n1146_1454# a_n775_1357#
+ a_n722_2122# a_n2092_n884# a_n5651_n1089# a_3632_1788# a_4480_n1552# a_5426_n2554#
+ a_3208_1454# a_4154_n884# a_664_2456# a_n6120_2456# a_6388_n216# a_n3152_1788# a_1133_n981#
+ a_6388_1120# a_n351_n2091# a_73_2025# a_5214_1788# a_28_n884# a_2670_786# a_6645_2251#
+ a_1822_2122# a_3677_1583# a_5002_n2554# a_5540_2122# a_n1668_786# a_n5174_118# a_2572_1454#
+ a_2148_n216# a_2148_1120# a_n5060_2122# a_3094_n550# a_4480_n1218# a_n2895_21# a_n2092_1454#
+ a_4154_1454# a_2405_2251# a_1088_n2554# a_3632_452# a_28_786# a_1186_2456# a_n5439_689#
+ a_1300_2122# a_709_n1649# a_6645_247# a_28_1454# a_2617_n2651# a_n1456_n1552# a_3730_n2220#
+ a_1557_n1757# a_n6075_247# a_n6711_2585# a_3094_n216# a_4101_247# a_n2206_n2220#
+ a_3094_1120# a_n5015_n647# a_5752_n1552# a_n3478_n2554# a_3632_118# a_4525_1691#
+ a_n1032_n1552# a_n5386_786# a_n5908_n884# a_1133_n1757# a_664_452# a_n1456_n1218#
+ a_n3054_n2554# a_n2471_21# a_n5651_2251# a_5797_2359# a_28_n1552# a_n2683_1583#
+ a_n563_n313# a_5752_n1218# a_n3319_1249# a_n4848_n550# a_n1032_n1218# a_n5810_786#
+ a_n6499_n1649# a_664_118# a_n1570_452# a_n1411_2251# a_1557_2359# a_n5908_1454#
+ a_1186_n1886# a_n4424_452# a_n6658_2456# a_n2728_n1552# a_n1782_n2220# a_28_n1218#
+ a_2829_n1757# a_3844_786# a_n4750_n884# a_n6075_n1649# a_n4326_n550# a_2458_452#
+ a_n5810_1788# a_n4848_n216# a_n934_n550# a_1300_786# a_n4848_1120# a_n6332_n884#
+ a_876_n884# a_n2304_n1552# a_n1570_118# a_n2418_2456# a_2405_n1757# a_n3576_n1886#
+ a_5850_n2554# a_n2471_581# a_n3531_1691# a_n5598_2122# a_n4424_118# a_n2728_n1218#
+ a_n4326_n2554# a_n3690_n550# a_6600_n1552# a_n298_n884# a_n608_2456# a_5752_n550#
+ a_876_786# a_n4326_n216# a_n3152_n1886# a_n4750_1454# a_1981_915# a_n4326_1120#
+ a_6698_1788# a_n1782_2456# a_n5272_n550# a_2458_118# a_5585_1917# a_n934_n216# a_n351_1249#
+ a_n1358_2122# a_n934_1120# a_3844_2456# a_n2304_n1218# a_n86_2456# a_876_1454# a_n6332_1454#
+ a_n3364_2456# a_1398_n884# a_1512_n550# a_2458_n1886# a_n3107_1023# a_5426_2456#
+ a_709_2251# a_6600_n1218# a_6176_452# a_2458_1788# a_n3690_n216# a_n1032_n550# a_n6499_n981#
+ a_1345_1917# a_n3690_1120# a_6176_1788# a_5752_n216# a_3208_n2554# a_n1782_786#
+ a_6009_689# a_5752_1120# a_n298_1454# a_n1880_n1552# a_1981_n1757# a_2784_2122#
+ a_497_n1315# a_n5272_n216# a_n298_n1886# a_2034_n1886# a_n4636_786# a_n5272_1120#
+ a_6009_2585# a_n2630_n2220# a_4790_2456# a_n4848_n1886# a_4366_2122# a_n2259_n981#
+ a_876_n1886# a_1398_1454# a_1512_n216# a_1512_1120# a_6600_452# a_6486_n2220# a_6176_118#
+ a_n1032_n216# a_n1032_1120# a_1936_n2220# a_n1880_n1218# a_n4424_n1886# a_550_2122#
+ a_452_n1886# a_6062_n2220# a_n4591_1917# a_4101_1583# a_2784_n2554# a_1512_n2220#
+ a_3465_n755# a_6600_118# a_n4000_n1886# a_285_n2425# a_3306_n1886# a_2360_n2554#
+ a_6388_786# a_n3902_n2220# a_n5015_2585# a_3889_n87# a_73_689# a_4737_2025# a_5585_581#
+ a_1769_1357# a_n2259_n2317# a_n775_n87# a_1345_n87# a_2193_n1423# a_3041_581# w_n6894_n2773#
+ a_n4750_n2554# a_921_2025# a_n1994_n884# a_2572_452# a_n563_2251# a_n4167_n2091#
+ a_5426_452# a_6221_2359# a_n3576_n884# a_n3743_n87# a_5638_n884# a_1557_n1089# a_285_2359#
+ a_n2471_n755# a_1610_n1552# a_2882_n1886# a_n4636_1788# a_n4803_2359# a_n1358_n1886#
+ a_3632_n2554# a_n4962_2122# a_2996_n550# a_2572_118# a_n1994_1454# a_1133_n1089#
+ a_3889_n1423# a_n6075_1691# a_5161_2025# a_n3054_n884# a_2193_1357# a_5116_n884#
+ a_5426_118# a_n6544_2122# a_4578_n550# a_1981_n981# a_n4114_1788# a_n3576_1454#
+ a_n3743_2025# a_1610_n1218# a_5638_1454# a_n722_1788# a_2617_n647# a_n396_452# a_3465_n1423#
+ a_338_n2220# a_6388_2456# a_5797_n313# a_n2304_2122# a_2996_n216# a_762_n550# a_n4167_21#
+ a_4480_n884# a_2996_1120# a_n5386_n2220# a_n4750_786# a_1822_1788# a_n6022_2122#
+ a_4056_n550# a_n3107_n2317# a_n5439_n2091# a_n3054_1454# a_5540_1788# a_4578_n216#
+ a_5116_1454# a_3041_n1423# a_4578_1120# a_1557_n313# a_6062_n884# a_n3364_452# a_2148_2456#
+ a_n184_n550# a_2829_n1089# a_n5060_1788# a_n820_452# a_2784_786# a_5797_n2317# a_n396_118#
+ a_240_n550# a_n5015_n2091# a_5638_786# a_3730_2122# a_762_n216# a_4904_n2554# a_1398_452#
+ a_1300_1788# a_762_1120# a_4056_n216# a_n722_n1552# a_4480_1454# a_2405_n1089# a_4056_1120#
+ a_n5863_n647# a_3730_n1886# a_4268_n2220# a_n1835_915# a_1088_2122# a_5373_n2317#
+ a_n86_n2554# a_n3364_118# a_n184_n216# a_6645_n421# a_6062_1454# a_3041_n647# a_3094_n1552#
+ a_n820_118# a_n184_1120# a_3094_2456# a_n2206_n1886# a_240_n216# a_4737_n1423# a_n2683_n2317#
+ a_240_1120# a_n1623_n647# a_1981_247# a_1822_452# a_1398_118# a_5585_1249# a_n6658_n2220#
+ a_2405_n421# a_n722_n1218# a_4313_n1423# a_n5484_n1552# a_n5227_1583# a_n4591_n2091#
+ a_126_786# a_4949_1023# a_3094_n1218# a_1345_1249# a_n6234_n2220# a_1981_n1089#
+ a_1822_118# a_n6711_n755# a_n6287_n87# a_n1623_n1423# a_n5060_n1552# a_n3576_786#
+ a_4313_n87# a_n1782_n1886# a_6645_n2317# a_3677_355# a_n5484_n1218# a_n820_n2554#
+ a_5540_452# a_n1032_786# a_n6756_n550# a_4366_n1552# a_6433_1357# a_n5651_n421#
+ a_n184_n2220# a_n4538_452# a_1133_355# a_n563_355# a_497_1357# a_n4848_2456# a_n3955_n2317#
+ a_n6711_n87# a_5116_n2220# a_6221_n2317# a_n5060_n1218# a_6388_n2554# a_n2940_n884#
+ a_762_n2220# a_n4591_1249# a_n5598_1788# a_n2516_n550# a_n6234_n550# a_n1411_n421#
+ a_n6756_n1552# a_5540_118# a_5373_1023# a_n3531_n2317# a_n6756_n216# a_n5863_n2091#
+ a_4366_n1218# a_n3531_355# a_n6756_1120# a_n4326_2456# a_n3788_2122# a_n4538_118#
+ a_n3955_1023# a_n1358_1788# a_n5439_581# a_n934_2456# a_n1880_n550# a_n6332_n1552#
+ a_1133_1023# a_3942_n550# a_497_21# a_n2516_n216# a_n2940_1454# a_n3107_2359# a_n2516_1120#
+ a_n4000_n884# a_n6234_n216# a_73_n2651# a_n6287_2025# a_n6756_n1218# a_n6234_1120#
+ a_n3690_2456# a_4949_915# a_n3266_2122# a_5752_2456# a_4692_n2220# a_5328_2122#
+ a_126_n884# a_5638_n1552# a_2784_1788# a_n4379_915# a_n5272_2456# a_n1880_n216#
+ a_3420_n550# a_n6332_452# a_n2630_n1886# a_3889_689# a_2405_915# a_n1880_1120# a_n2047_2025#
+ a_2617_2585# a_5752_786# a_4366_1788# a_3942_n216# a_n6332_n1218# a_3942_1120# a_5797_2251#
+ a_1512_2456# a_5002_n550# a_5214_n1552# a_6486_n1886# a_n4000_1454# a_4366_452#
+ a_1345_689# a_n775_689# a_4692_2122# a_n1032_2456# a_1936_n1886# a_n4803_n2317#
+ a_5638_n1218# a_550_1788# a_126_1454# a_6221_n313# a_709_n421# a_n4803_915# a_6274_2122#
+ a_n2206_786# a_1557_2251# a_3420_n216# a_n6332_118# a_n775_n1983# a_6062_n1886#
+ a_3420_1120# a_285_n313# a_n4803_n313# a_1512_n1886# a_n6711_n2091# a_n3743_689#
+ a_5002_n216# a_6009_n755# a_5214_n1218# a_n1668_n2220# a_5002_1120# a_4366_118#
+ a_2034_2122# a_n351_n1983# a_73_1917# a_n5863_2585# a_5964_n2220# a_240_786# a_n4167_n647#
+ a_n1244_n2220# a_n775_n647# a_4790_n1552# a_3041_2585# a_n3902_n1886# a_3677_1691#
+ a_n3690_786# a_n1623_2585# a_n3266_n1552# a_5540_n2220# a_n6544_786# a_n2092_n2554#
+ a_n6287_n2651# a_709_n1757# a_6645_355# a_n4538_n884# a_3677_n1649# a_4790_n1218#
+ a_4578_786# a_n4000_786# a_1398_n2554# a_n139_1583# a_n6075_355# a_n1199_21# a_4101_355#
+ a_n3266_n1218# a_n1835_247# a_n5015_n755# a_6009_581# a_2034_786# a_3253_n1649#
+ a_2148_n1552# a_n3478_n550# a_5964_n884# a_n2516_n2220# a_n4962_1788# a_n3788_n2554#
+ a_n4538_1454# a_n5484_n884# a_n2683_1691# a_n6544_1788# a_4525_n981# a_n4538_n1552#
+ a_n563_n421# a_1724_n884# a_n3319_1357# a_2148_n1218# a_n3364_n2554# a_n1244_n884#
+ a_338_n1886# a_n6499_1023# a_n6499_n1757# a_n3478_n216# a_n3478_1120# a_3306_n884#
+ a_5964_1454# a_n2304_1788# a_4949_n1649# a_2996_2456# a_6486_n550# a_n4114_n1552#
+ a_n5386_n1886# a_921_n2651# a_n5484_1454# a_n6022_1788# a_n2630_2122# a_n2259_1023#
+ a_2829_1583# a_4578_2456# a_n4538_n1218# a_n6075_n1757# a_1724_1454# a_2670_n884#
+ a_4525_n1649# a_4480_452# a_n4212_2122# a_2246_n550# a_n6287_689# a_n1244_1454#
+ a_2246_n2554# a_3730_1788# a_n820_2122# a_3306_1454# a_n3478_452# a_4313_689# a_762_2456#
+ a_6486_n216# a_n4114_n1218# a_73_581# a_338_2122# a_n934_452# a_6486_1120# a_n1835_n1649#
+ a_n2940_786# a_4056_2456# a_4101_n1649# a_4268_n1886# a_1088_1788# a_n1199_n1315#
+ a_n184_2456# a_n3531_n981# a_n351_1357# a_4480_118# a_2670_1454# a_2246_n216# a_n3690_n1552#
+ a_664_n2554# a_n4636_n2554# a_n1411_n1649# a_n6711_689# a_2246_1120# a_240_2456#
+ a_3208_786# a_n3902_452# a_n3478_118# a_n934_118# a_n6658_n1886# a_6221_2251# a_2996_n1552#
+ a_3253_1583# a_n4212_n2554# a_240_n2554# a_1936_452# a_285_2251# a_n4803_2251# a_4949_2359#
+ a_497_n1423# a_n1835_1583# a_n3107_n313# a_4949_247# a_n3690_n1218# a_n6234_n1886#
+ a_3518_n2554# a_2572_n1552# a_n3902_118# a_n4379_247# a_2405_247# a_n5272_452# a_n4167_2585#
+ a_4692_786# a_2996_n1218# a_3889_2025# a_n2940_n2220# a_n775_2585# a_1936_118# a_1769_n2091#
+ a_n3902_n884# a_n184_n1886# a_n5908_n2554# a_n4962_n1552# a_2572_n1218# a_n4803_247#
+ a_5116_n1886# a_5002_786# a_4101_1691# a_762_n1886# a_n1146_786# a_n2047_n1315#
+ a_1345_n2091# a_n5272_118# a_5373_2359# a_n2842_n550# a_1822_n2220# a_3730_452#
+ a_1981_1023# a_n6756_2456# a_n3788_1788# a_4904_n550# a_n3955_2359# a_n4962_n1218#
+ a_73_1249# a_n3902_1454# a_n2728_452# a_n4424_n550# a_4737_1917# a_3844_n1552# a_1133_2359#
+ a_n608_n1552# a_974_n884# a_2670_n2554# a_n2516_2456# a_n2259_n2425# a_4268_n884#
+ a_n5696_2122# a_n6234_2456# a_n2842_n216# a_n3266_1788# a_921_1917# a_n1146_n2554#
+ a_3730_118# a_n2842_1120# a_n2895_2025# a_6009_n1315# a_3420_n1552# a_4692_n1886#
+ a_5328_1788# a_4904_n216# a_762_452# a_n5484_786# a_1769_n647# a_4904_1120# a_5850_n550#
+ a_n396_n884# a_n4167_n1983# a_1936_2122# a_n510_n550# a_n2728_118# a_n4424_n216#
+ a_n4424_1120# a_n1880_2456# a_452_n884# a_709_n1089# a_3844_n1218# a_n1456_2122#
+ a_n608_n1218# a_3942_2456# a_n3319_n1315# a_2617_n2091# a_3518_2122# a_n5174_2122#
+ a_974_1454# a_4692_1788# a_1610_n550# a_n5810_n1552# a_n6446_452# a_4268_1454# a_3420_n1218#
+ a_762_118# a_6274_1788# a_5850_n216# a_5161_1917# a_n510_n216# a_5850_1120# a_n396_1454#
+ a_n510_1120# a_2882_2122# a_3420_2456# a_452_1454# a_n3743_1917# a_n934_n2220# a_3942_786#
+ a_n1668_n1886# a_3942_n2554# a_5002_2456# a_5585_n1315# a_2617_n755# a_2034_1788#
+ a_1610_n216# a_n5810_n1218# a_n6446_118# a_n6075_n981# a_1610_1120# a_5797_n421#
+ a_n2418_n2554# a_2193_n647# a_5964_n1886# a_n510_n2220# a_2360_2122# a_n2895_n1315#
+ a_n6499_n1089# a_n5439_n1983# a_n1244_n1886# a_4904_452# a_5161_n1315# a_n3107_n2425#
+ a_1557_n421# a_5540_n1886# a_974_786# a_n5696_n2220# a_5797_n2425# a_2193_n87# a_n6075_n1089#
+ a_n2471_n1315# a_n5015_n1983# a_n4379_1583# a_n987_1583# a_5585_21# a_4904_118#
+ a_n5863_n755# a_n5272_n2220# a_n6658_786# a_n3107_2251# a_5373_n2425# a_6274_452#
+ a_n4591_n87# a_n1994_n2554# a_n1880_786# a_3041_n755# a_n2728_n884# a_n4114_786#
+ a_n6446_n884# a_n2683_n2425# a_4578_n2220# a_n1623_n755# a_1981_355# a_5585_1357#
+ a_3889_581# a_n2516_n1886# a_n1570_n2554# a_6433_n1315# a_2148_786# a_n2842_452#
+ a_6274_118# a_n4591_n1983# a_n5227_1691# a_n2206_n884# a_4154_n2220# a_n139_n2317#
+ a_4313_2025# a_n1668_n550# a_1345_581# a_n775_581# a_1345_1357# a_n5386_n550# a_5161_21#
+ a_n3743_n1315# a_n2728_1454# a_n6499_2359# a_6176_n1552# a_n6446_1454# a_n3478_2456#
+ a_4949_n313# a_n1570_n884# a_n1146_n550# a_n6544_n2220# a_n2842_118# a_n3743_581#
+ a_3632_n884# a_6645_n2425# a_n2630_1788# a_n1668_n216# a_3208_n550# a_n2259_2359#
+ a_n1668_1120# a_n2206_1454# a_n3152_n884# a_n5386_n216# a_5214_n884# a_n5386_1120#
+ a_6176_n1218# a_n3955_n2425# a_n4212_1788# a_n6120_n2220# a_6486_786# a_6221_n2425#
+ a_n820_1788# a_2617_21# a_n2842_n2554# a_n4591_1357# a_6433_n647# a_2572_n550# a_338_1788#
+ a_6486_2456# a_n1146_n216# a_n1570_1454# a_1769_2585# a_n2683_915# a_n1146_1120#
+ a_6600_2122# a_n1199_2025# a_n2092_n550# a_3632_1454# a_3208_n216# a_497_n647# a_n5863_n1983#
+ a_5426_n2220# a_285_n1649# a_6698_n2554# a_n3531_n2425# a_3208_1120# a_664_2122#
+ a_n6120_2122# a_4154_n550# a_n3152_1454# a_2193_n2651# a_5214_1454# a_2670_452#
+ a_2246_2456# a_28_n550# a_5373_n313# a_6274_n2554# a_5002_n2220# a_n5908_786# a_2572_n216#
+ a_n1668_452# a_2572_1120# a_4737_1249# a_n6287_1917# a_n3955_n313# a_1724_n2554#
+ a_n2092_n216# a_n2092_1120# a_4154_n216# a_4154_1120# a_1133_n313# a_1088_n2220#
+ a_1186_2122# a_28_452# a_921_1249# a_n2047_1917# a_28_n216# a_2670_118# a_1300_n2554#
+ a_28_1120# a_3889_n2651# a_5161_n87# a_n987_n2317# a_n1668_118# a_2193_2585# a_n2940_n1886#
+ a_n4803_n2425# a_n3478_n2220# a_6221_n421# a_3465_n2651# a_28_118# a_n563_n2317#
+ a_n5386_452# a_n5908_n550# a_285_n421# a_n4803_n421# a_n6711_n1983# a_n3054_n2220#
+ a_5161_1249# a_3041_n2651# a_n3743_1249# a_2882_786# a_n5810_n884# a_1822_n1886#
+ a_5116_786# a_n4167_n755# a_n5810_452# a_4525_1023# a_1981_2359# a_n5908_n216# a_n5386_118#
+ a_n6287_581# a_2617_n87# a_n5908_1120# a_n775_n755# a_4313_581# a_1186_n1552# a_n6658_2122#
+ a_n2047_n87# a_3844_452# a_n4750_n550# a_6698_n884# a_5797_915# a_921_21# a_n5696_1788#
+ a_3677_n981# a_n5810_1454# a_1300_452# a_n5439_2025# a_n2842_2456# a_4737_n2651#
+ a_n5810_118# a_n6711_581# a_n6332_n550# a_876_n550# a_n3576_n1552# a_5850_n2220#
+ a_n2418_2122# a_3677_n1757# a_4904_2456# a_1186_n1218# a_3253_915# a_1936_1788#
+ a_2458_n884# a_n139_1691# a_n4424_2456# a_n4326_n2220# a_n1456_1788# a_n5598_n2554#
+ a_3844_118# a_6176_n884# a_n608_2122# a_n298_n550# a_n5598_786# a_3518_1788# a_n5174_1788#
+ a_n4750_n216# a_4313_n2651# a_876_452# a_n1835_355# a_n3152_n1552# a_126_n2554#
+ a_2193_689# a_n4750_1120# a_4949_2251# a_3253_n1757# a_6698_1454# a_n1782_2122#
+ a_3844_2122# a_1300_118# a_n4591_21# a_n6332_n216# a_876_n216# a_n5651_915# a_n86_2122#
+ a_n3576_n1218# a_n5174_n2554# a_n3054_786# a_876_1120# a_n6332_1120# a_n1623_n2651#
+ a_n3364_2122# a_1398_n550# a_n510_786# a_n3531_1023# a_5850_2456# a_2458_n1552#
+ a_n510_2456# a_2882_1788# a_5426_2122# a_285_915# a_2458_1454# a_n4591_689# a_n934_n1886#
+ a_1088_786# a_6176_1454# a_n298_n216# a_3208_n2220# a_876_118# a_n1782_452# a_n3152_n1218#
+ a_n298_1120# a_n298_n1552# a_6433_2585# a_2034_n1552# a_1610_2456# a_n4636_452#
+ a_n2683_n981# a_4790_2122# a_497_2585# a_n4848_n1552# a_876_n1552# a_2360_1788#
+ a_1398_n216# a_4949_n1757# a_n510_n1886# a_2458_n1218# a_1398_1120# a_n3319_n647#
+ a_4056_n2554# a_2829_1691# a_n6499_n313# a_1512_786# a_n1782_118# a_5373_2251# a_n4424_n1552#
+ a_452_n1552# a_4525_n1757# a_n5696_n1886# a_n298_n1218# a_2034_n1218# a_n4636_118#
+ a_n3955_2251# a_n4848_n1218# a_n6446_n2554# a_n2259_n313# a_876_n1218# a_2784_n2220#
+ a_2193_21# a_1133_2251# a_n1835_n1757# a_n4000_n1552# a_4101_n1757# a_n5272_n1886#
+ a_n1199_n1423# a_n2683_247# a_n4424_n1218# a_452_n1218# a_n6022_n2554# a_3306_n1552#
+ a_n1411_n1757# a_4578_n1886# a_2360_n2220# a_n1623_21# a_6388_452# a_n396_n2554#
+ a_5850_786# a_n1994_786# a_5328_n2554# a_n4000_n1218# a_n351_n647# a_974_n2554#
+ a_3253_1691# a_n4848_786# a_n4636_n884# a_4154_n1886# a_n6287_1249# a_73_n2091#
+ a_n4750_n2220# a_n1835_1691# a_n3107_n421# a_4949_355# a_n5015_n87# a_3306_n1218#
+ a_n2304_786# a_n1994_n550# a_6388_118# a_550_n2554# a_n4379_355# a_n2047_1249# a_2405_355#
+ a_n3576_n550# a_n4114_n884# a_3889_1917# a_n6544_n1886# a_5638_n550# a_n722_n884#
+ a_1769_n1983# a_2882_n1552# a_n4636_1454# a_6221_915# a_n1668_2456# a_n5386_2456#
+ a_n1358_n1552# a_3632_n2220# a_n1994_n216# a_1822_n884# a_n6120_n1886# a_n4803_355#
+ a_n1994_1120# a_n3054_n550# a_1345_n1983# a_5161_689# a_5540_n884# a_n2047_n1423#
+ a_5116_n550# a_n3576_n216# a_n4114_1454# a_n5060_n884# a_n3576_1120# a_6600_1788#
+ a_n1146_2456# a_5638_n216# a_n6022_786# a_5638_1120# a_n722_1454# a_2882_n1218#
+ a_5426_n1886# a_4480_n2554# a_3208_2456# a_664_1788# a_n6120_1788# a_4101_n981#
+ a_6388_2122# a_1300_n884# a_n1358_n1218# a_n139_915# a_73_1357# a_4480_n550# a_4056_786#
+ a_n4750_452# a_n6075_1023# a_1822_1454# a_6645_1583# a_n3054_n216# a_n4379_n2317#
+ a_5002_n1886# a_n3054_1120# a_5116_n216# a_5540_1454# a_5116_1120# a_2572_2456#
+ a_1981_n313# a_6062_n550# a_2148_2122# a_n5060_1454# a_2784_452# a_n2895_1917# a_n2092_2456#
+ a_n3107_915# a_2405_1583# a_4154_2456# a_6009_n1423# a_1088_n1886# a_1769_n755#
+ a_n6287_n2091# a_5797_247# a_5638_452# a_2617_689# a_1186_1788# a_1300_1454# a_4904_n2220#
+ a_4480_n216# a_n4750_118# a_4480_1120# a_28_2456# a_n2047_689# a_3677_n1089# a_2617_n1983#
+ a_n1456_n2554# a_n3319_n1423# a_3730_n1552# a_3253_247# a_n86_n2220# a_6062_n216#
+ a_6062_1120# a_2784_118# a_709_915# a_3094_2122# a_n2206_n1552# a_n3478_n1886# a_5752_n2554#
+ a_n3319_2585# a_3253_n1089# a_n6499_2251# a_n1032_n2554# a_5638_118# a_n5651_247#
+ a_3730_n1218# a_n3054_n1886# a_n5651_1583# a_28_n2554# a_5585_n1423# a_285_247#
+ a_126_452# a_n2259_2251# a_n6287_21# a_n2206_n1218# a_n4962_786# a_2193_n755# a_n5227_n2317#
+ a_4525_2359# a_n2895_n1423# a_n1411_1583# a_n5908_2456# a_n5598_n884# a_n3576_452#
+ a_5161_n1423# a_2996_786# a_4949_n1089# a_n2728_n2554# a_n1782_n1552# a_n6658_1788#
+ a_921_n2091# a_n820_n2220# a_126_118# a_n1032_452# a_n2471_n1423# a_n4379_1691#
+ a_3465_2025# a_n1358_n884# a_n351_2585# a_n987_1691# a_n4848_2122# a_4525_n1089#
+ a_n2304_n2554# a_3306_786# a_n2418_1788# a_5850_n1886# a_6388_n2220# a_n3576_118#
+ a_n2940_n550# a_n5598_1454# a_n1782_n1218# a_n4326_n1886# a_6600_n2554# a_n1835_n1089#
+ a_n608_1788# a_4101_n1089# a_n1032_118# a_2784_n884# a_n4750_2456# a_497_n2651#
+ a_n4326_2122# a_n1782_1788# a_n1358_1454# a_3844_1788# a_n934_2122# a_n86_1788#
+ a_876_2456# a_n6332_2456# a_4366_n884# a_n1411_n1089# a_338_786# a_n3364_1788# a_n3531_2359#
+ a_n2940_n216# a_6433_n1423# a_n2940_1120# a_5426_1788# a_n4000_n550# a_4313_1917#
+ a_4790_786# a_709_1583# a_n139_n2425# a_n3690_2122# a_5585_n647# a_3208_n1886# a_550_n884#
+ a_n1880_n2554# a_5752_2122# a_n298_2456# a_n3319_21# a_n3788_786# a_126_n550# a_n3743_n1423#
+ a_2784_1454# a_n5272_2122# a_n5227_n981# a_n2471_2025# a_n2630_n1552# a_4790_1788#
+ a_4949_n421# a_5752_452# a_n1244_786# a_4366_1454# a_1345_n647# a_1398_2456# a_1512_2122#
+ a_n4000_n216# a_6486_n1552# a_n4000_1120# a_n1032_2122# a_3889_1249# a_1936_n1552#
+ a_126_n216# a_n5015_689# a_550_1454# a_126_1120# a_1981_2251# a_6221_247# a_n2206_452#
+ a_n2630_n1218# a_6062_n1552# a_5752_118# a_6433_n755# a_1512_n1552# a_n1199_1917#
+ a_2784_n1886# a_n5651_n2317# a_6486_n1218# a_497_n755# a_285_n1757# a_1936_n1218#
+ a_n4591_n647# a_240_452# a_2360_n1886# a_n2206_118# a_n775_n1315# a_6062_n1218#
+ a_5373_n421# a_n3902_n1552# a_n139_247# a_4737_1357# a_1512_n1218# a_n3690_452#
+ a_n3955_n421# a_n2259_n1649# a_2193_581# a_n6544_452# a_n2092_n2220# a_1133_n421#
+ a_n351_n1315# a_5964_786# a_n4750_n1886# a_240_118# a_n2895_1249# a_921_1357# a_n4962_n884#
+ a_n4538_n550# a_n3107_247# a_n3902_n1218# a_4578_452# a_n4000_452# a_3677_1023#
+ a_n987_n2425# a_n563_1583# a_1398_n2220# a_3420_786# a_n2895_n87# a_n6544_n884#
+ a_n3690_118# a_n4591_581# a_n2418_786# a_1610_n2554# a_n6544_118# a_2034_452# a_n86_786#
+ a_709_247# a_n563_n2425# a_5964_n550# a_n2304_n884# a_n4962_1454# a_n4538_n216#
+ a_3632_n1886# a_n6022_n884# a_n3788_n2220# a_4578_118# a_n4000_118# a_n4538_1120#
+ a_n1994_2456# a_n5484_n550# a_5161_1357# a_n6544_1454# a_452_786# a_n6711_2025#
+ a_n3576_2456# a_n3743_1357# a_1724_n550# a_2034_118# a_5638_2456# a_n3364_n2220#
+ a_n1244_n550# a_338_n1552# a_3730_n884# a_6388_1788# a_5964_n216# a_3306_n550# a_5964_1120#
+ a_n2304_1454# a_2996_2122# a_n5484_n216# a_n5386_n1552# a_n6075_2359# a_n3107_n1649#
+ a_n6756_786# a_n5484_1120# a_n6022_1454# a_1088_n884# a_n3054_2456# a_n2683_1023#
+ a_5116_2456# a_4525_n313# a_4578_2122# a_2148_1788# a_1724_n216# a_1724_1120# a_n5439_1917#
+ a_2670_n550# a_n4212_786# a_338_n1218# a_5797_n1649# a_n1244_n216# a_n1244_1120#
+ a_3306_n216# a_2246_n2220# a_3730_1454# a_5585_2585# a_3306_1120# a_4904_n1886#
+ a_762_2122# a_n5386_n1218# a_n722_n2554# a_2246_786# a_4480_2456# a_n2940_452# a_4056_2122#
+ a_5373_n1649# a_4268_n1552# a_1088_1454# a_n86_n1886# a_6062_2456# a_3094_n2554#
+ a_3094_1788# a_n184_2122# a_1345_2585# a_2670_n216# a_n4636_n2220# a_2670_1120#
+ a_n139_n981# a_664_n2220# a_240_2122# a_n2683_n1649# a_3208_452# a_n6658_n1552#
+ a_n2940_118# a_4268_n1218# a_n5484_n2554# a_n4212_n2220# a_240_n2220# a_4313_1249#
+ a_n3531_n313# a_n6234_n1552# a_3208_118# a_3518_n2220# a_3465_n87# a_n5060_n2554#
+ a_5161_581# a_n3319_n755# a_n6658_n1218# a_n4591_2585# a_n6499_n421# a_4692_452#
+ a_6645_n1649# a_n351_n87# a_n820_n1886# a_4366_n2554# a_n3788_n884# a_6009_2025#
+ a_n3902_n550# a_n5863_n87# a_n6234_n1218# a_n184_n1552# a_n5908_n2220# a_2829_n981#
+ a_n3955_n1649# a_n4848_1788# a_n2259_n421# a_5116_n1552# a_6221_n1649# a_6388_n1886#
+ a_5002_452# a_n1146_452# a_762_n1552# a_497_n87# a_4692_118# a_n1199_1249# a_n3266_n884#
+ a_n6756_n2554# a_n2683_355# a_n3531_n1649# a_n6756_2122# a_5328_n884# a_285_n1089#
+ a_n3788_1454# a_n4326_1788# a_n3902_n216# a_n184_n1218# a_2617_581# a_n3902_1120#
+ a_2193_n2091# a_n934_1788# a_5116_n1218# a_5002_118# a_4101_1023# a_921_n87# a_n6332_n2554#
+ a_n1146_118# a_n2047_581# a_762_n1218# a_n351_n755# a_n2940_2456# a_974_n550# a_2670_n2220#
+ a_n2516_2122# a_4692_n884# a_73_n1983# a_n6287_1357# a_n6234_2122# a_4268_n550#
+ a_n3690_1788# a_n3266_1454# a_5752_1788# a_5638_n2554# a_n1146_n2220# a_4692_n1552#
+ a_5328_1454# a_6274_n884# a_n5484_452# a_n987_915# a_n396_n550# a_1557_915# a_n5272_1788#
+ a_3253_n981# a_n5015_2025# a_n1880_2122# a_452_n550# a_n2047_1357# a_n1835_n981#
+ a_1557_n2317# a_3942_2122# a_974_n216# a_3889_n2091# a_5797_1583# a_1512_1788# a_5214_n2554#
+ a_974_1120# a_2034_n884# a_2360_786# a_n4000_2456# a_4692_1454# a_4268_n216# a_4268_1120#
+ a_n1032_1788# a_n4803_n1649# a_5214_786# a_n3955_915# a_4692_n1218# a_n1358_786#
+ a_n5484_118# a_4525_2251# a_126_2456# a_6274_1454# a_n396_n216# a_1133_n2317# a_3465_n2091#
+ a_1557_1583# a_n4167_n1315# a_n396_1120# a_3420_2122# a_452_n216# a_n2895_689# a_n1411_915#
+ a_452_1120# a_3942_452# a_n1668_n1552# a_3942_n2220# a_5002_2122# a_2034_1454# a_3041_n2091#
+ a_n2418_n2220# a_5964_n1552# a_6645_1691# a_n1244_n1552# a_4790_n2554# a_n184_786#
+ a_n4379_n2425# a_1981_n421# a_2829_n2317# a_3942_118# a_n1668_n1218# a_n3266_n2554#
+ a_974_452# a_n5696_786# a_73_n647# a_5540_n1552# a_6433_n87# a_n6075_n313# a_n6287_n1983#
+ a_2405_1691# a_n2092_n1886# a_5797_355# a_n5439_1249# a_5964_n1218# a_n3152_786#
+ a_2405_n2317# a_n5439_n1315# a_n1244_n1218# a_4737_n2091# a_n3531_2251# a_3677_2359#
+ a_n6658_452# a_3253_355# a_1398_n1886# a_n1994_n2220# a_1186_786# a_5540_n1218#
+ a_974_118# a_n1880_452# a_n2728_n550# a_n5015_n1315# a_2148_n2554# a_4313_n2091#
+ a_n4114_452# a_n6446_n550# a_n5651_355# a_n2516_n1552# a_n3788_n1886# a_n1570_n2220#
+ a_n4538_2456# a_2148_452# a_n1623_n2091# a_n6658_118# a_n5651_1691# a_n2630_n884#
+ a_1610_786# a_n2206_n550# a_285_355# a_n4538_n2554# a_n1880_118# a_n3319_n87# a_n2728_n216#
+ a_1981_n2317# a_n4114_118# a_n5015_581# a_n2728_1120# a_n4212_n884# a_n6446_n216#
+ a_n3364_n1886# a_n5227_n2425# a_n6446_1120# a_n820_n884# a_n1411_1691# a_n3478_2122#
+ a_5964_2456# a_338_n884# a_n2516_n1218# a_2996_1788# a_n1570_n550# a_n4114_n2554#
+ a_2148_118# a_921_n1983# a_n5484_2456# a_n6499_915# a_3632_n550# a_n5227_1023# a_n2683_2359#
+ a_n4591_n1315# a_4525_915# a_n2630_1454# a_n2206_n216# a_n2206_1120# a_4578_1788#
+ a_n1199_n2651# a_3465_1917# a_n3152_n550# a_1724_2456# a_5214_n550# a_n4212_1454#
+ a_6486_452# a_3465_689# a_n1244_2456# a_2246_n1886# a_n820_1454# a_3306_2456# a_762_1788#
+ a_n2842_n2220# a_n1570_n216# a_338_1454# a_6486_2122# a_n4379_n981# a_n4326_786#
+ a_n1570_1120# a_4056_1788# a_3632_n216# a_n351_689# a_n987_n981# a_3632_1120# a_6698_n2220#
+ a_n3152_n216# a_n3152_1120# a_5214_n216# a_n5863_689# a_n184_1788# a_5214_1120#
+ a_2670_2456# a_n4636_n1886# a_n3690_n2554# a_664_n1886# a_6486_118# a_240_1788#
+ a_2246_2122# a_497_689# a_6274_n2220# a_n5908_452# a_6221_1583# a_709_1691# a_2996_n2554#
+ a_1724_n2220# a_5585_n755# a_n5863_n1315# a_n4212_n1886# a_240_n1886# a_285_1583#
+ a_n4803_1583# a_n2471_1917# a_1300_n2220# a_n6711_21# a_921_689# a_3518_n1886# a_2572_n2554#
+ a_1557_247# a_n987_247# a_1345_n755# a_n5908_118# a_n2047_n2651# a_n6120_786# a_3889_1357#
+ a_n2940_n1552# a_6698_786# a_4737_21# a_6221_355# a_n5908_n1886# a_n4962_n2554#
+ a_n3955_247# a_73_2585# a_4154_786# a_2617_2025# a_n6075_2251# a_n5651_n2425# a_n1411_247#
+ a_n608_786# a_n5696_n884# a_n2940_n1218# a_2882_452# a_n5810_n550# a_5116_452# a_n4591_n755#
+ a_1822_n1552# a_n6756_1788# a_6009_n2651# a_1936_n884# a_n3902_2456# a_n775_n1423#
+ a_n139_355# a_3844_n2554# a_4101_2359# a_n1456_n884# a_n6711_n1315# a_n608_n2554#
+ a_n5174_n884# a_3518_n884# a_n3319_n2651# a_4313_21# a_n2516_1788# a_n2259_n1757#
+ a_2670_n1886# a_6698_n550# a_2882_118# a_n6234_1788# a_n5810_n216# a_n351_n1423#
+ a_n5696_1454# a_n5863_2025# a_n5810_1120# a_1822_n1218# a_n1146_n1886# a_3420_n2554#
+ a_5116_118# a_n2895_1357# a_n2842_2122# a_4737_n647# a_n3107_355# a_4904_2122# a_1936_1454#
+ a_3041_2025# a_n563_1691# a_2882_n884# a_n4424_2122# a_2458_n550# a_n2092_786# a_n1880_1788#
+ a_n1456_1454# a_n5598_n2220# a_3942_1788# a_n1623_2025# a_6176_n550# a_921_n647#
+ a_n5598_452# a_6433_689# a_3518_1454# a_n5174_1454# a_974_2456# a_5585_n2651# a_6698_n216#
+ a_126_n2220# a_n5810_n2554# a_6698_1120# a_4268_2456# a_3677_n313# a_709_355# a_2360_n884#
+ a_n5174_n2220# a_n3054_452# a_n2895_n2651# a_n510_452# a_5850_2122# a_n396_2456#
+ a_5161_n2651# a_3420_1788# a_n510_2122# a_2458_n216# a_n139_1023# a_2882_1454# a_2458_1120#
+ a_n6711_1917# a_452_2456# a_6176_n216# a_n934_n1552# a_5328_786# a_1088_452# a_6176_1120#
+ a_3942_n1886# a_n5598_118# a_5002_1788# a_n2471_n2651# a_1610_2122# a_5161_n647#
+ a_n2418_n1886# a_n3054_118# a_2360_1454# a_n510_n1552# a_n510_118# a_n3743_n647#
+ a_n3107_n1757# a_4056_n2220# a_4525_n421# a_1512_452# a_n934_n1218# a_1088_118#
+ a_n6499_247# a_n3319_689# a_n5696_n1552# a_5797_n1757# a_4525_247#
X0 a_5850_n2554# a_5797_n2425# a_5752_n2554# w_n6894_n2773# sky130_fd_pr__pfet_01v8 ad=0.1421 pd=1.56 as=0.1421 ps=1.56 w=0.49 l=0.2
X1 a_n3266_n884# a_n3319_n755# a_n3364_n884# w_n6894_n2773# sky130_fd_pr__pfet_01v8 ad=0.1421 pd=1.56 as=0.1421 ps=1.56 w=0.49 l=0.2
X2 a_n2206_1788# a_n2259_1691# a_n2304_1788# w_n6894_n2773# sky130_fd_pr__pfet_01v8 ad=0.1421 pd=1.56 as=0.1421 ps=1.56 w=0.49 l=0.2
X3 a_n722_n550# a_n775_n647# a_n820_n550# w_n6894_n2773# sky130_fd_pr__pfet_01v8 ad=0.1421 pd=1.56 as=0.1421 ps=1.56 w=0.49 l=0.2
X4 a_n4750_2122# a_n4803_2251# a_n4848_2122# w_n6894_n2773# sky130_fd_pr__pfet_01v8 ad=0.1421 pd=1.56 as=0.1421 ps=1.56 w=0.49 l=0.2
X5 a_550_1788# a_497_1917# a_452_1788# w_n6894_n2773# sky130_fd_pr__pfet_01v8 ad=0.1421 pd=1.56 as=0.1421 ps=1.56 w=0.49 l=0.2
X6 a_6486_n2220# a_6433_n2091# a_6388_n2220# w_n6894_n2773# sky130_fd_pr__pfet_01v8 ad=0.1421 pd=1.56 as=0.1421 ps=1.56 w=0.49 l=0.2
X7 a_126_452# a_73_581# a_28_452# w_n6894_n2773# sky130_fd_pr__pfet_01v8 ad=0.1421 pd=1.56 as=0.1421 ps=1.56 w=0.49 l=0.2
X8 a_n4538_n550# a_n4591_n647# a_n4636_n550# w_n6894_n2773# sky130_fd_pr__pfet_01v8 ad=0.1421 pd=1.56 as=0.1421 ps=1.56 w=0.49 l=0.2
X9 a_4154_n1218# a_4101_n1089# a_4056_n1218# w_n6894_n2773# sky130_fd_pr__pfet_01v8 ad=0.1421 pd=1.56 as=0.1421 ps=1.56 w=0.49 l=0.2
X10 a_550_n1218# a_497_n1315# a_452_n1218# w_n6894_n2773# sky130_fd_pr__pfet_01v8 ad=0.1421 pd=1.56 as=0.1421 ps=1.56 w=0.49 l=0.2
X11 a_n298_1788# a_n351_1917# a_n396_1788# w_n6894_n2773# sky130_fd_pr__pfet_01v8 ad=0.1421 pd=1.56 as=0.1421 ps=1.56 w=0.49 l=0.2
X12 a_4790_n1886# a_4737_n1983# a_4692_n1886# w_n6894_n2773# sky130_fd_pr__pfet_01v8 ad=0.1421 pd=1.56 as=0.1421 ps=1.56 w=0.49 l=0.2
X13 a_6274_n216# a_6221_n313# a_6176_n216# w_n6894_n2773# sky130_fd_pr__pfet_01v8 ad=0.1421 pd=1.56 as=0.1421 ps=1.56 w=0.49 l=0.2
X14 a_5426_1120# a_5373_1023# a_5328_1120# w_n6894_n2773# sky130_fd_pr__pfet_01v8 ad=0.1421 pd=1.56 as=0.1421 ps=1.56 w=0.49 l=0.2
X15 a_n4962_118# a_n5015_21# a_n5060_118# w_n6894_n2773# sky130_fd_pr__pfet_01v8 ad=0.1421 pd=1.56 as=0.1421 ps=1.56 w=0.49 l=0.2
X16 a_n4962_n2220# a_n5015_n2091# a_n5060_n2220# w_n6894_n2773# sky130_fd_pr__pfet_01v8 ad=0.1421 pd=1.56 as=0.1421 ps=1.56 w=0.49 l=0.2
X17 a_n1358_n1552# a_n1411_n1649# a_n1456_n1552# w_n6894_n2773# sky130_fd_pr__pfet_01v8 ad=0.1421 pd=1.56 as=0.1421 ps=1.56 w=0.49 l=0.2
X18 a_n5386_118# a_n5439_21# a_n5484_118# w_n6894_n2773# sky130_fd_pr__pfet_01v8 ad=0.1421 pd=1.56 as=0.1421 ps=1.56 w=0.49 l=0.2
X19 a_n2630_2122# a_n2683_2251# a_n2728_2122# w_n6894_n2773# sky130_fd_pr__pfet_01v8 ad=0.1421 pd=1.56 as=0.1421 ps=1.56 w=0.49 l=0.2
X20 a_n5810_118# a_n5863_21# a_n5908_118# w_n6894_n2773# sky130_fd_pr__pfet_01v8 ad=0.1421 pd=1.56 as=0.1421 ps=1.56 w=0.49 l=0.2
X21 a_6274_n2220# a_6221_n2317# a_6176_n2220# w_n6894_n2773# sky130_fd_pr__pfet_01v8 ad=0.1421 pd=1.56 as=0.1421 ps=1.56 w=0.49 l=0.2
X22 a_n510_n2554# a_n563_n2425# a_n608_n2554# w_n6894_n2773# sky130_fd_pr__pfet_01v8 ad=0.1421 pd=1.56 as=0.1421 ps=1.56 w=0.49 l=0.2
X23 a_n3054_2122# a_n3107_2251# a_n3152_2122# w_n6894_n2773# sky130_fd_pr__pfet_01v8 ad=0.1421 pd=1.56 as=0.1421 ps=1.56 w=0.49 l=0.2
X24 a_n2418_n550# a_n2471_n647# a_n2516_n550# w_n6894_n2773# sky130_fd_pr__pfet_01v8 ad=0.1421 pd=1.56 as=0.1421 ps=1.56 w=0.49 l=0.2
X25 a_974_2122# a_921_2025# a_876_2122# w_n6894_n2773# sky130_fd_pr__pfet_01v8 ad=0.1421 pd=1.56 as=0.1421 ps=1.56 w=0.49 l=0.2
X26 a_n5598_1454# a_n5651_1583# a_n5696_1454# w_n6894_n2773# sky130_fd_pr__pfet_01v8 ad=0.1421 pd=1.56 as=0.1421 ps=1.56 w=0.49 l=0.2
X27 a_6486_2456# a_6433_2585# a_6388_2456# w_n6894_n2773# sky130_fd_pr__pfet_01v8 ad=0.1421 pd=1.56 as=0.1421 ps=1.56 w=0.49 l=0.2
X28 a_n6022_1454# a_n6075_1583# a_n6120_1454# w_n6894_n2773# sky130_fd_pr__pfet_01v8 ad=0.1421 pd=1.56 as=0.1421 ps=1.56 w=0.49 l=0.2
X29 a_762_n550# a_709_n421# a_664_n550# w_n6894_n2773# sky130_fd_pr__pfet_01v8 ad=0.1421 pd=1.56 as=0.1421 ps=1.56 w=0.49 l=0.2
X30 a_2458_n2554# a_2405_n2425# a_2360_n2554# w_n6894_n2773# sky130_fd_pr__pfet_01v8 ad=0.1421 pd=1.56 as=0.1421 ps=1.56 w=0.49 l=0.2
X31 a_n4114_118# a_n4167_21# a_n4212_118# w_n6894_n2773# sky130_fd_pr__pfet_01v8 ad=0.1421 pd=1.56 as=0.1421 ps=1.56 w=0.49 l=0.2
X32 a_6274_118# a_6221_247# a_6176_118# w_n6894_n2773# sky130_fd_pr__pfet_01v8 ad=0.1421 pd=1.56 as=0.1421 ps=1.56 w=0.49 l=0.2
X33 a_4154_n216# a_4101_n313# a_4056_n216# w_n6894_n2773# sky130_fd_pr__pfet_01v8 ad=0.1421 pd=1.56 as=0.1421 ps=1.56 w=0.49 l=0.2
X34 a_n510_n550# a_n563_n421# a_n608_n550# w_n6894_n2773# sky130_fd_pr__pfet_01v8 ad=0.1421 pd=1.56 as=0.1421 ps=1.56 w=0.49 l=0.2
X35 a_3306_1120# a_3253_1023# a_3208_1120# w_n6894_n2773# sky130_fd_pr__pfet_01v8 ad=0.1421 pd=1.56 as=0.1421 ps=1.56 w=0.49 l=0.2
X36 a_6486_n884# a_6433_n755# a_6388_n884# w_n6894_n2773# sky130_fd_pr__pfet_01v8 ad=0.1421 pd=1.56 as=0.1421 ps=1.56 w=0.49 l=0.2
X37 a_5426_1788# a_5373_1691# a_5328_1788# w_n6894_n2773# sky130_fd_pr__pfet_01v8 ad=0.1421 pd=1.56 as=0.1421 ps=1.56 w=0.49 l=0.2
X38 a_6698_118# a_6645_247# a_6600_118# w_n6894_n2773# sky130_fd_pr__pfet_01v8 ad=0.1421 pd=1.56 as=0.1421 ps=1.56 w=0.49 l=0.2
X39 a_n1146_n1552# a_n1199_n1423# a_n1244_n1552# w_n6894_n2773# sky130_fd_pr__pfet_01v8 ad=0.1421 pd=1.56 as=0.1421 ps=1.56 w=0.49 l=0.2
X40 a_n4538_118# a_n4591_21# a_n4636_118# w_n6894_n2773# sky130_fd_pr__pfet_01v8 ad=0.1421 pd=1.56 as=0.1421 ps=1.56 w=0.49 l=0.2
X41 a_n2630_n1218# a_n2683_n1089# a_n2728_n1218# w_n6894_n2773# sky130_fd_pr__pfet_01v8 ad=0.1421 pd=1.56 as=0.1421 ps=1.56 w=0.49 l=0.2
X42 a_n3902_n216# a_n3955_n313# a_n4000_n216# w_n6894_n2773# sky130_fd_pr__pfet_01v8 ad=0.1421 pd=1.56 as=0.1421 ps=1.56 w=0.49 l=0.2
X43 a_2034_n2220# a_1981_n2317# a_1936_n2220# w_n6894_n2773# sky130_fd_pr__pfet_01v8 ad=0.1421 pd=1.56 as=0.1421 ps=1.56 w=0.49 l=0.2
X44 a_1398_n1886# a_1345_n1983# a_1300_n1886# w_n6894_n2773# sky130_fd_pr__pfet_01v8 ad=0.1421 pd=1.56 as=0.1421 ps=1.56 w=0.49 l=0.2
X45 a_n6022_452# a_n6075_355# a_n6120_452# w_n6894_n2773# sky130_fd_pr__pfet_01v8 ad=0.1421 pd=1.56 as=0.1421 ps=1.56 w=0.49 l=0.2
X46 a_6062_n2220# a_6009_n2091# a_5964_n2220# w_n6894_n2773# sky130_fd_pr__pfet_01v8 ad=0.1421 pd=1.56 as=0.1421 ps=1.56 w=0.49 l=0.2
X47 a_n298_n2554# a_n351_n2651# a_n396_n2554# w_n6894_n2773# sky130_fd_pr__pfet_01v8 ad=0.1421 pd=1.56 as=0.1421 ps=1.56 w=0.49 l=0.2
X48 a_n4962_2122# a_n5015_2025# a_n5060_2122# w_n6894_n2773# sky130_fd_pr__pfet_01v8 ad=0.1421 pd=1.56 as=0.1421 ps=1.56 w=0.49 l=0.2
X49 a_n6446_452# a_n6499_355# a_n6544_452# w_n6894_n2773# sky130_fd_pr__pfet_01v8 ad=0.1421 pd=1.56 as=0.1421 ps=1.56 w=0.49 l=0.2
X50 a_n3478_1454# a_n3531_1583# a_n3576_1454# w_n6894_n2773# sky130_fd_pr__pfet_01v8 ad=0.1421 pd=1.56 as=0.1421 ps=1.56 w=0.49 l=0.2
X51 a_3730_n550# a_3677_n421# a_3632_n550# w_n6894_n2773# sky130_fd_pr__pfet_01v8 ad=0.1421 pd=1.56 as=0.1421 ps=1.56 w=0.49 l=0.2
X52 a_5426_118# a_5373_247# a_5328_118# w_n6894_n2773# sky130_fd_pr__pfet_01v8 ad=0.1421 pd=1.56 as=0.1421 ps=1.56 w=0.49 l=0.2
X53 a_4366_2456# a_4313_2585# a_4268_2456# w_n6894_n2773# sky130_fd_pr__pfet_01v8 ad=0.1421 pd=1.56 as=0.1421 ps=1.56 w=0.49 l=0.2
X54 a_550_118# a_497_21# a_452_118# w_n6894_n2773# sky130_fd_pr__pfet_01v8 ad=0.1421 pd=1.56 as=0.1421 ps=1.56 w=0.49 l=0.2
X55 a_2246_n2554# a_2193_n2651# a_2148_n2554# w_n6894_n2773# sky130_fd_pr__pfet_01v8 ad=0.1421 pd=1.56 as=0.1421 ps=1.56 w=0.49 l=0.2
X56 a_n1782_n1552# a_n1835_n1649# a_n1880_n1552# w_n6894_n2773# sky130_fd_pr__pfet_01v8 ad=0.1421 pd=1.56 as=0.1421 ps=1.56 w=0.49 l=0.2
X57 a_n5810_n216# a_n5863_n87# a_n5908_n216# w_n6894_n2773# sky130_fd_pr__pfet_01v8 ad=0.1421 pd=1.56 as=0.1421 ps=1.56 w=0.49 l=0.2
X58 a_1186_1120# a_1133_1023# a_1088_1120# w_n6894_n2773# sky130_fd_pr__pfet_01v8 ad=0.1421 pd=1.56 as=0.1421 ps=1.56 w=0.49 l=0.2
X59 a_n6234_786# a_n6287_689# a_n6332_786# w_n6894_n2773# sky130_fd_pr__pfet_01v8 ad=0.1421 pd=1.56 as=0.1421 ps=1.56 w=0.49 l=0.2
X60 a_974_118# a_921_21# a_876_118# w_n6894_n2773# sky130_fd_pr__pfet_01v8 ad=0.1421 pd=1.56 as=0.1421 ps=1.56 w=0.49 l=0.2
X61 a_4366_n884# a_4313_n755# a_4268_n884# w_n6894_n2773# sky130_fd_pr__pfet_01v8 ad=0.1421 pd=1.56 as=0.1421 ps=1.56 w=0.49 l=0.2
X62 a_3306_1788# a_3253_1691# a_3208_1788# w_n6894_n2773# sky130_fd_pr__pfet_01v8 ad=0.1421 pd=1.56 as=0.1421 ps=1.56 w=0.49 l=0.2
X63 a_n6234_n216# a_n6287_n87# a_n6332_n216# w_n6894_n2773# sky130_fd_pr__pfet_01v8 ad=0.1421 pd=1.56 as=0.1421 ps=1.56 w=0.49 l=0.2
X64 a_n4750_n2220# a_n4803_n2317# a_n4848_n2220# w_n6894_n2773# sky130_fd_pr__pfet_01v8 ad=0.1421 pd=1.56 as=0.1421 ps=1.56 w=0.49 l=0.2
X65 a_n2418_n1218# a_n2471_n1315# a_n2516_n1218# w_n6894_n2773# sky130_fd_pr__pfet_01v8 ad=0.1421 pd=1.56 as=0.1421 ps=1.56 w=0.49 l=0.2
X66 a_n6658_786# a_n6711_689# a_n6756_786# w_n6894_n2773# sky130_fd_pr__pfet_01v8 ad=0.1421 pd=1.56 as=0.1421 ps=1.56 w=0.49 l=0.2
X67 a_n1782_n216# a_n1835_n313# a_n1880_n216# w_n6894_n2773# sky130_fd_pr__pfet_01v8 ad=0.1421 pd=1.56 as=0.1421 ps=1.56 w=0.49 l=0.2
X68 a_126_n216# a_73_n87# a_28_n216# w_n6894_n2773# sky130_fd_pr__pfet_01v8 ad=0.1421 pd=1.56 as=0.1421 ps=1.56 w=0.49 l=0.2
X69 a_1822_n2220# a_1769_n2091# a_1724_n2220# w_n6894_n2773# sky130_fd_pr__pfet_01v8 ad=0.1421 pd=1.56 as=0.1421 ps=1.56 w=0.49 l=0.2
X70 a_1186_n1886# a_1133_n1757# a_1088_n1886# w_n6894_n2773# sky130_fd_pr__pfet_01v8 ad=0.1421 pd=1.56 as=0.1421 ps=1.56 w=0.49 l=0.2
X71 a_5638_n550# a_5585_n647# a_5540_n550# w_n6894_n2773# sky130_fd_pr__pfet_01v8 ad=0.1421 pd=1.56 as=0.1421 ps=1.56 w=0.49 l=0.2
X72 a_1822_2122# a_1769_2025# a_1724_2122# w_n6894_n2773# sky130_fd_pr__pfet_01v8 ad=0.1421 pd=1.56 as=0.1421 ps=1.56 w=0.49 l=0.2
X73 a_5850_2122# a_5797_2251# a_5752_2122# w_n6894_n2773# sky130_fd_pr__pfet_01v8 ad=0.1421 pd=1.56 as=0.1421 ps=1.56 w=0.49 l=0.2
X74 a_n86_n2554# a_n139_n2425# a_n184_n2554# w_n6894_n2773# sky130_fd_pr__pfet_01v8 ad=0.1421 pd=1.56 as=0.1421 ps=1.56 w=0.49 l=0.2
X75 a_1610_n550# a_1557_n421# a_1512_n550# w_n6894_n2773# sky130_fd_pr__pfet_01v8 ad=0.1421 pd=1.56 as=0.1421 ps=1.56 w=0.49 l=0.2
X76 a_4790_1454# a_4737_1357# a_4692_1454# w_n6894_n2773# sky130_fd_pr__pfet_01v8 ad=0.1421 pd=1.56 as=0.1421 ps=1.56 w=0.49 l=0.2
X77 a_n3902_n2554# a_n3955_n2425# a_n4000_n2554# w_n6894_n2773# sky130_fd_pr__pfet_01v8 ad=0.1421 pd=1.56 as=0.1421 ps=1.56 w=0.49 l=0.2
X78 a_2246_2456# a_2193_2585# a_2148_2456# w_n6894_n2773# sky130_fd_pr__pfet_01v8 ad=0.1421 pd=1.56 as=0.1421 ps=1.56 w=0.49 l=0.2
X79 a_3942_118# a_3889_21# a_3844_118# w_n6894_n2773# sky130_fd_pr__pfet_01v8 ad=0.1421 pd=1.56 as=0.1421 ps=1.56 w=0.49 l=0.2
X80 a_n6446_2456# a_n6499_2359# a_n6544_2456# w_n6894_n2773# sky130_fd_pr__pfet_01v8 ad=0.1421 pd=1.56 as=0.1421 ps=1.56 w=0.49 l=0.2
X81 a_n1782_118# a_n1835_247# a_n1880_118# w_n6894_n2773# sky130_fd_pr__pfet_01v8 ad=0.1421 pd=1.56 as=0.1421 ps=1.56 w=0.49 l=0.2
X82 a_n3690_n216# a_n3743_n87# a_n3788_n216# w_n6894_n2773# sky130_fd_pr__pfet_01v8 ad=0.1421 pd=1.56 as=0.1421 ps=1.56 w=0.49 l=0.2
X83 a_n3054_n2554# a_n3107_n2425# a_n3152_n2554# w_n6894_n2773# sky130_fd_pr__pfet_01v8 ad=0.1421 pd=1.56 as=0.1421 ps=1.56 w=0.49 l=0.2
X84 a_n934_n1552# a_n987_n1649# a_n1032_n1552# w_n6894_n2773# sky130_fd_pr__pfet_01v8 ad=0.1421 pd=1.56 as=0.1421 ps=1.56 w=0.49 l=0.2
X85 a_2246_n884# a_2193_n755# a_2148_n884# w_n6894_n2773# sky130_fd_pr__pfet_01v8 ad=0.1421 pd=1.56 as=0.1421 ps=1.56 w=0.49 l=0.2
X86 a_1186_1788# a_1133_1691# a_1088_1788# w_n6894_n2773# sky130_fd_pr__pfet_01v8 ad=0.1421 pd=1.56 as=0.1421 ps=1.56 w=0.49 l=0.2
X87 a_n4114_n216# a_n4167_n87# a_n4212_n216# w_n6894_n2773# sky130_fd_pr__pfet_01v8 ad=0.1421 pd=1.56 as=0.1421 ps=1.56 w=0.49 l=0.2
X88 a_n4538_n2220# a_n4591_n2091# a_n4636_n2220# w_n6894_n2773# sky130_fd_pr__pfet_01v8 ad=0.1421 pd=1.56 as=0.1421 ps=1.56 w=0.49 l=0.2
X89 a_n2842_n1886# a_n2895_n1983# a_n2940_n1886# w_n6894_n2773# sky130_fd_pr__pfet_01v8 ad=0.1421 pd=1.56 as=0.1421 ps=1.56 w=0.49 l=0.2
X90 a_n5810_n1552# a_n5863_n1423# a_n5908_n1552# w_n6894_n2773# sky130_fd_pr__pfet_01v8 ad=0.1421 pd=1.56 as=0.1421 ps=1.56 w=0.49 l=0.2
X91 a_n2206_n1218# a_n2259_n1089# a_n2304_n1218# w_n6894_n2773# sky130_fd_pr__pfet_01v8 ad=0.1421 pd=1.56 as=0.1421 ps=1.56 w=0.49 l=0.2
X92 a_n6446_n884# a_n6499_n981# a_n6544_n884# w_n6894_n2773# sky130_fd_pr__pfet_01v8 ad=0.1421 pd=1.56 as=0.1421 ps=1.56 w=0.49 l=0.2
X93 a_5850_452# a_5797_355# a_5752_452# w_n6894_n2773# sky130_fd_pr__pfet_01v8 ad=0.1421 pd=1.56 as=0.1421 ps=1.56 w=0.49 l=0.2
X94 a_1610_n2220# a_1557_n2317# a_1512_n2220# w_n6894_n2773# sky130_fd_pr__pfet_01v8 ad=0.1421 pd=1.56 as=0.1421 ps=1.56 w=0.49 l=0.2
X95 a_6698_1454# a_6645_1583# a_6600_1454# w_n6894_n2773# sky130_fd_pr__pfet_01v8 ad=0.1421 pd=1.56 as=0.1421 ps=1.56 w=0.49 l=0.2
X96 a_3518_n550# a_3465_n647# a_3420_n550# w_n6894_n2773# sky130_fd_pr__pfet_01v8 ad=0.1421 pd=1.56 as=0.1421 ps=1.56 w=0.49 l=0.2
X97 a_2882_n1552# a_2829_n1649# a_2784_n1552# w_n6894_n2773# sky130_fd_pr__pfet_01v8 ad=0.1421 pd=1.56 as=0.1421 ps=1.56 w=0.49 l=0.2
X98 a_2670_118# a_2617_21# a_2572_118# w_n6894_n2773# sky130_fd_pr__pfet_01v8 ad=0.1421 pd=1.56 as=0.1421 ps=1.56 w=0.49 l=0.2
X99 a_3518_n1218# a_3465_n1315# a_3420_n1218# w_n6894_n2773# sky130_fd_pr__pfet_01v8 ad=0.1421 pd=1.56 as=0.1421 ps=1.56 w=0.49 l=0.2
X100 a_2670_1454# a_2617_1357# a_2572_1454# w_n6894_n2773# sky130_fd_pr__pfet_01v8 ad=0.1421 pd=1.56 as=0.1421 ps=1.56 w=0.49 l=0.2
X101 a_n4326_2456# a_n4379_2359# a_n4424_2456# w_n6894_n2773# sky130_fd_pr__pfet_01v8 ad=0.1421 pd=1.56 as=0.1421 ps=1.56 w=0.49 l=0.2
X102 a_n3902_786# a_n3955_915# a_n4000_786# w_n6894_n2773# sky130_fd_pr__pfet_01v8 ad=0.1421 pd=1.56 as=0.1421 ps=1.56 w=0.49 l=0.2
X103 a_n1570_n216# a_n1623_n87# a_n1668_n216# w_n6894_n2773# sky130_fd_pr__pfet_01v8 ad=0.1421 pd=1.56 as=0.1421 ps=1.56 w=0.49 l=0.2
X104 a_338_n216# a_285_n313# a_240_n216# w_n6894_n2773# sky130_fd_pr__pfet_01v8 ad=0.1421 pd=1.56 as=0.1421 ps=1.56 w=0.49 l=0.2
X105 a_5002_n216# a_4949_n313# a_4904_n216# w_n6894_n2773# sky130_fd_pr__pfet_01v8 ad=0.1421 pd=1.56 as=0.1421 ps=1.56 w=0.49 l=0.2
X106 a_n722_n1552# a_n775_n1423# a_n820_n1552# w_n6894_n2773# sky130_fd_pr__pfet_01v8 ad=0.1421 pd=1.56 as=0.1421 ps=1.56 w=0.49 l=0.2
X107 a_n1994_n216# a_n2047_n87# a_n2092_n216# w_n6894_n2773# sky130_fd_pr__pfet_01v8 ad=0.1421 pd=1.56 as=0.1421 ps=1.56 w=0.49 l=0.2
X108 a_n4326_n2220# a_n4379_n2317# a_n4424_n2220# w_n6894_n2773# sky130_fd_pr__pfet_01v8 ad=0.1421 pd=1.56 as=0.1421 ps=1.56 w=0.49 l=0.2
X109 a_n5174_1120# a_n5227_1023# a_n5272_1120# w_n6894_n2773# sky130_fd_pr__pfet_01v8 ad=0.1421 pd=1.56 as=0.1421 ps=1.56 w=0.49 l=0.2
X110 a_n1146_1120# a_n1199_1249# a_n1244_1120# w_n6894_n2773# sky130_fd_pr__pfet_01v8 ad=0.1421 pd=1.56 as=0.1421 ps=1.56 w=0.49 l=0.2
X111 a_5002_452# a_4949_355# a_4904_452# w_n6894_n2773# sky130_fd_pr__pfet_01v8 ad=0.1421 pd=1.56 as=0.1421 ps=1.56 w=0.49 l=0.2
X112 a_n5598_n1552# a_n5651_n1649# a_n5696_n1552# w_n6894_n2773# sky130_fd_pr__pfet_01v8 ad=0.1421 pd=1.56 as=0.1421 ps=1.56 w=0.49 l=0.2
X113 a_n1994_n1218# a_n2047_n1315# a_n2092_n1218# w_n6894_n2773# sky130_fd_pr__pfet_01v8 ad=0.1421 pd=1.56 as=0.1421 ps=1.56 w=0.49 l=0.2
X114 a_n4326_n884# a_n4379_n981# a_n4424_n884# w_n6894_n2773# sky130_fd_pr__pfet_01v8 ad=0.1421 pd=1.56 as=0.1421 ps=1.56 w=0.49 l=0.2
X115 a_n2842_452# a_n2895_581# a_n2940_452# w_n6894_n2773# sky130_fd_pr__pfet_01v8 ad=0.1421 pd=1.56 as=0.1421 ps=1.56 w=0.49 l=0.2
X116 a_5002_n2554# a_4949_n2425# a_4904_n2554# w_n6894_n2773# sky130_fd_pr__pfet_01v8 ad=0.1421 pd=1.56 as=0.1421 ps=1.56 w=0.49 l=0.2
X117 a_6062_2122# a_6009_2025# a_5964_2122# w_n6894_n2773# sky130_fd_pr__pfet_01v8 ad=0.1421 pd=1.56 as=0.1421 ps=1.56 w=0.49 l=0.2
X118 a_4578_1454# a_4525_1583# a_4480_1454# w_n6894_n2773# sky130_fd_pr__pfet_01v8 ad=0.1421 pd=1.56 as=0.1421 ps=1.56 w=0.49 l=0.2
X119 a_1398_n550# a_1345_n647# a_1300_n550# w_n6894_n2773# sky130_fd_pr__pfet_01v8 ad=0.1421 pd=1.56 as=0.1421 ps=1.56 w=0.49 l=0.2
X120 a_2670_n1552# a_2617_n1423# a_2572_n1552# w_n6894_n2773# sky130_fd_pr__pfet_01v8 ad=0.1421 pd=1.56 as=0.1421 ps=1.56 w=0.49 l=0.2
X121 a_1822_118# a_1769_21# a_1724_118# w_n6894_n2773# sky130_fd_pr__pfet_01v8 ad=0.1421 pd=1.56 as=0.1421 ps=1.56 w=0.49 l=0.2
X122 a_n86_n216# a_n139_n313# a_n184_n216# w_n6894_n2773# sky130_fd_pr__pfet_01v8 ad=0.1421 pd=1.56 as=0.1421 ps=1.56 w=0.49 l=0.2
X123 a_4790_786# a_4737_689# a_4692_786# w_n6894_n2773# sky130_fd_pr__pfet_01v8 ad=0.1421 pd=1.56 as=0.1421 ps=1.56 w=0.49 l=0.2
X124 a_5638_n2220# a_5585_n2091# a_5540_n2220# w_n6894_n2773# sky130_fd_pr__pfet_01v8 ad=0.1421 pd=1.56 as=0.1421 ps=1.56 w=0.49 l=0.2
X125 a_3306_n1218# a_3253_n1089# a_3208_n1218# w_n6894_n2773# sky130_fd_pr__pfet_01v8 ad=0.1421 pd=1.56 as=0.1421 ps=1.56 w=0.49 l=0.2
X126 a_n3266_452# a_n3319_581# a_n3364_452# w_n6894_n2773# sky130_fd_pr__pfet_01v8 ad=0.1421 pd=1.56 as=0.1421 ps=1.56 w=0.49 l=0.2
X127 a_3730_452# a_3677_355# a_3632_452# w_n6894_n2773# sky130_fd_pr__pfet_01v8 ad=0.1421 pd=1.56 as=0.1421 ps=1.56 w=0.49 l=0.2
X128 a_n2206_2456# a_n2259_2359# a_n2304_2456# w_n6894_n2773# sky130_fd_pr__pfet_01v8 ad=0.1421 pd=1.56 as=0.1421 ps=1.56 w=0.49 l=0.2
X129 a_n3690_452# a_n3743_581# a_n3788_452# w_n6894_n2773# sky130_fd_pr__pfet_01v8 ad=0.1421 pd=1.56 as=0.1421 ps=1.56 w=0.49 l=0.2
X130 a_2246_118# a_2193_21# a_2148_118# w_n6894_n2773# sky130_fd_pr__pfet_01v8 ad=0.1421 pd=1.56 as=0.1421 ps=1.56 w=0.49 l=0.2
X131 a_2882_n216# a_2829_n313# a_2784_n216# w_n6894_n2773# sky130_fd_pr__pfet_01v8 ad=0.1421 pd=1.56 as=0.1421 ps=1.56 w=0.49 l=0.2
X132 a_2034_1120# a_1981_1023# a_1936_1120# w_n6894_n2773# sky130_fd_pr__pfet_01v8 ad=0.1421 pd=1.56 as=0.1421 ps=1.56 w=0.49 l=0.2
X133 a_n4114_n2220# a_n4167_n2091# a_n4212_n2220# w_n6894_n2773# sky130_fd_pr__pfet_01v8 ad=0.1421 pd=1.56 as=0.1421 ps=1.56 w=0.49 l=0.2
X134 a_550_2456# a_497_2585# a_452_2456# w_n6894_n2773# sky130_fd_pr__pfet_01v8 ad=0.1421 pd=1.56 as=0.1421 ps=1.56 w=0.49 l=0.2
X135 a_n5174_1788# a_n5227_1691# a_n5272_1788# w_n6894_n2773# sky130_fd_pr__pfet_01v8 ad=0.1421 pd=1.56 as=0.1421 ps=1.56 w=0.49 l=0.2
X136 a_n1146_1788# a_n1199_1917# a_n1244_1788# w_n6894_n2773# sky130_fd_pr__pfet_01v8 ad=0.1421 pd=1.56 as=0.1421 ps=1.56 w=0.49 l=0.2
X137 a_n5386_n1552# a_n5439_n1423# a_n5484_n1552# w_n6894_n2773# sky130_fd_pr__pfet_01v8 ad=0.1421 pd=1.56 as=0.1421 ps=1.56 w=0.49 l=0.2
X138 a_n2206_n884# a_n2259_n981# a_n2304_n884# w_n6894_n2773# sky130_fd_pr__pfet_01v8 ad=0.1421 pd=1.56 as=0.1421 ps=1.56 w=0.49 l=0.2
X139 a_4790_n2554# a_4737_n2651# a_4692_n2554# w_n6894_n2773# sky130_fd_pr__pfet_01v8 ad=0.1421 pd=1.56 as=0.1421 ps=1.56 w=0.49 l=0.2
X140 a_n298_2456# a_n351_2585# a_n396_2456# w_n6894_n2773# sky130_fd_pr__pfet_01v8 ad=0.1421 pd=1.56 as=0.1421 ps=1.56 w=0.49 l=0.2
X141 a_2458_1454# a_2405_1583# a_2360_1454# w_n6894_n2773# sky130_fd_pr__pfet_01v8 ad=0.1421 pd=1.56 as=0.1421 ps=1.56 w=0.49 l=0.2
X142 a_126_n1552# a_73_n1423# a_28_n1552# w_n6894_n2773# sky130_fd_pr__pfet_01v8 ad=0.1421 pd=1.56 as=0.1421 ps=1.56 w=0.49 l=0.2
X143 a_550_n884# a_497_n755# a_452_n884# w_n6894_n2773# sky130_fd_pr__pfet_01v8 ad=0.1421 pd=1.56 as=0.1421 ps=1.56 w=0.49 l=0.2
X144 a_n3478_786# a_n3531_915# a_n3576_786# w_n6894_n2773# sky130_fd_pr__pfet_01v8 ad=0.1421 pd=1.56 as=0.1421 ps=1.56 w=0.49 l=0.2
X145 a_4154_452# a_4101_355# a_4056_452# w_n6894_n2773# sky130_fd_pr__pfet_01v8 ad=0.1421 pd=1.56 as=0.1421 ps=1.56 w=0.49 l=0.2
X146 a_3942_n1218# a_3889_n1315# a_3844_n1218# w_n6894_n2773# sky130_fd_pr__pfet_01v8 ad=0.1421 pd=1.56 as=0.1421 ps=1.56 w=0.49 l=0.2
X147 a_n6658_1454# a_n6711_1357# a_n6756_1454# w_n6894_n2773# sky130_fd_pr__pfet_01v8 ad=0.1421 pd=1.56 as=0.1421 ps=1.56 w=0.49 l=0.2
X148 a_n1994_452# a_n2047_581# a_n2092_452# w_n6894_n2773# sky130_fd_pr__pfet_01v8 ad=0.1421 pd=1.56 as=0.1421 ps=1.56 w=0.49 l=0.2
X149 a_n6658_n1886# a_n6711_n1983# a_n6756_n1886# w_n6894_n2773# sky130_fd_pr__pfet_01v8 ad=0.1421 pd=1.56 as=0.1421 ps=1.56 w=0.49 l=0.2
X150 a_n298_n884# a_n351_n755# a_n396_n884# w_n6894_n2773# sky130_fd_pr__pfet_01v8 ad=0.1421 pd=1.56 as=0.1421 ps=1.56 w=0.49 l=0.2
X151 a_338_452# a_285_355# a_240_452# w_n6894_n2773# sky130_fd_pr__pfet_01v8 ad=0.1421 pd=1.56 as=0.1421 ps=1.56 w=0.49 l=0.2
X152 a_5426_n2220# a_5373_n2317# a_5328_n2220# w_n6894_n2773# sky130_fd_pr__pfet_01v8 ad=0.1421 pd=1.56 as=0.1421 ps=1.56 w=0.49 l=0.2
X153 a_4578_452# a_4525_355# a_4480_452# w_n6894_n2773# sky130_fd_pr__pfet_01v8 ad=0.1421 pd=1.56 as=0.1421 ps=1.56 w=0.49 l=0.2
X154 a_3730_n1886# a_3677_n1757# a_3632_n1886# w_n6894_n2773# sky130_fd_pr__pfet_01v8 ad=0.1421 pd=1.56 as=0.1421 ps=1.56 w=0.49 l=0.2
X155 a_6698_n1552# a_6645_n1649# a_6600_n1552# w_n6894_n2773# sky130_fd_pr__pfet_01v8 ad=0.1421 pd=1.56 as=0.1421 ps=1.56 w=0.49 l=0.2
X156 a_3094_n1218# a_3041_n1315# a_2996_n1218# w_n6894_n2773# sky130_fd_pr__pfet_01v8 ad=0.1421 pd=1.56 as=0.1421 ps=1.56 w=0.49 l=0.2
X157 a_n2418_452# a_n2471_581# a_n2516_452# w_n6894_n2773# sky130_fd_pr__pfet_01v8 ad=0.1421 pd=1.56 as=0.1421 ps=1.56 w=0.49 l=0.2
X158 a_5214_n216# a_5161_n87# a_5116_n216# w_n6894_n2773# sky130_fd_pr__pfet_01v8 ad=0.1421 pd=1.56 as=0.1421 ps=1.56 w=0.49 l=0.2
X159 a_1398_118# a_1345_21# a_1300_118# w_n6894_n2773# sky130_fd_pr__pfet_01v8 ad=0.1421 pd=1.56 as=0.1421 ps=1.56 w=0.49 l=0.2
X160 a_2034_1788# a_1981_1691# a_1936_1788# w_n6894_n2773# sky130_fd_pr__pfet_01v8 ad=0.1421 pd=1.56 as=0.1421 ps=1.56 w=0.49 l=0.2
X161 a_3942_1120# a_3889_1249# a_3844_1120# w_n6894_n2773# sky130_fd_pr__pfet_01v8 ad=0.1421 pd=1.56 as=0.1421 ps=1.56 w=0.49 l=0.2
X162 a_n2206_786# a_n2259_915# a_n2304_786# w_n6894_n2773# sky130_fd_pr__pfet_01v8 ad=0.1421 pd=1.56 as=0.1421 ps=1.56 w=0.49 l=0.2
X163 a_4366_786# a_4313_689# a_4268_786# w_n6894_n2773# sky130_fd_pr__pfet_01v8 ad=0.1421 pd=1.56 as=0.1421 ps=1.56 w=0.49 l=0.2
X164 a_n5174_n1552# a_n5227_n1649# a_n5272_n1552# w_n6894_n2773# sky130_fd_pr__pfet_01v8 ad=0.1421 pd=1.56 as=0.1421 ps=1.56 w=0.49 l=0.2
X165 a_n5598_2122# a_n5651_2251# a_n5696_2122# w_n6894_n2773# sky130_fd_pr__pfet_01v8 ad=0.1421 pd=1.56 as=0.1421 ps=1.56 w=0.49 l=0.2
X166 a_n722_1454# a_n775_1357# a_n820_1454# w_n6894_n2773# sky130_fd_pr__pfet_01v8 ad=0.1421 pd=1.56 as=0.1421 ps=1.56 w=0.49 l=0.2
X167 a_n2630_786# a_n2683_915# a_n2728_786# w_n6894_n2773# sky130_fd_pr__pfet_01v8 ad=0.1421 pd=1.56 as=0.1421 ps=1.56 w=0.49 l=0.2
X168 a_3306_452# a_3253_355# a_3208_452# w_n6894_n2773# sky130_fd_pr__pfet_01v8 ad=0.1421 pd=1.56 as=0.1421 ps=1.56 w=0.49 l=0.2
X169 a_n6022_2122# a_n6075_2251# a_n6120_2122# w_n6894_n2773# sky130_fd_pr__pfet_01v8 ad=0.1421 pd=1.56 as=0.1421 ps=1.56 w=0.49 l=0.2
X170 a_n1146_452# a_n1199_581# a_n1244_452# w_n6894_n2773# sky130_fd_pr__pfet_01v8 ad=0.1421 pd=1.56 as=0.1421 ps=1.56 w=0.49 l=0.2
X171 a_n5386_n550# a_n5439_n647# a_n5484_n550# w_n6894_n2773# sky130_fd_pr__pfet_01v8 ad=0.1421 pd=1.56 as=0.1421 ps=1.56 w=0.49 l=0.2
X172 a_n1358_n550# a_n1411_n421# a_n1456_n550# w_n6894_n2773# sky130_fd_pr__pfet_01v8 ad=0.1421 pd=1.56 as=0.1421 ps=1.56 w=0.49 l=0.2
X173 a_n4538_1454# a_n4591_1357# a_n4636_1454# w_n6894_n2773# sky130_fd_pr__pfet_01v8 ad=0.1421 pd=1.56 as=0.1421 ps=1.56 w=0.49 l=0.2
X174 a_n1570_n2220# a_n1623_n2091# a_n1668_n2220# w_n6894_n2773# sky130_fd_pr__pfet_01v8 ad=0.1421 pd=1.56 as=0.1421 ps=1.56 w=0.49 l=0.2
X175 a_n6446_n1886# a_n6499_n1757# a_n6544_n1886# w_n6894_n2773# sky130_fd_pr__pfet_01v8 ad=0.1421 pd=1.56 as=0.1421 ps=1.56 w=0.49 l=0.2
X176 a_5214_n2220# a_5161_n2091# a_5116_n2220# w_n6894_n2773# sky130_fd_pr__pfet_01v8 ad=0.1421 pd=1.56 as=0.1421 ps=1.56 w=0.49 l=0.2
X177 a_5426_2456# a_5373_2359# a_5328_2456# w_n6894_n2773# sky130_fd_pr__pfet_01v8 ad=0.1421 pd=1.56 as=0.1421 ps=1.56 w=0.49 l=0.2
X178 a_6486_n1552# a_6433_n1423# a_6388_n1552# w_n6894_n2773# sky130_fd_pr__pfet_01v8 ad=0.1421 pd=1.56 as=0.1421 ps=1.56 w=0.49 l=0.2
X179 a_3094_786# a_3041_689# a_2996_786# w_n6894_n2773# sky130_fd_pr__pfet_01v8 ad=0.1421 pd=1.56 as=0.1421 ps=1.56 w=0.49 l=0.2
X180 a_6274_1120# a_6221_1023# a_6176_1120# w_n6894_n2773# sky130_fd_pr__pfet_01v8 ad=0.1421 pd=1.56 as=0.1421 ps=1.56 w=0.49 l=0.2
X181 a_3094_n216# a_3041_n87# a_2996_n216# w_n6894_n2773# sky130_fd_pr__pfet_01v8 ad=0.1421 pd=1.56 as=0.1421 ps=1.56 w=0.49 l=0.2
X182 a_1398_n2554# a_1345_n2651# a_1300_n2554# w_n6894_n2773# sky130_fd_pr__pfet_01v8 ad=0.1421 pd=1.56 as=0.1421 ps=1.56 w=0.49 l=0.2
X183 a_5426_n884# a_5373_n981# a_5328_n884# w_n6894_n2773# sky130_fd_pr__pfet_01v8 ad=0.1421 pd=1.56 as=0.1421 ps=1.56 w=0.49 l=0.2
X184 a_3518_786# a_3465_689# a_3420_786# w_n6894_n2773# sky130_fd_pr__pfet_01v8 ad=0.1421 pd=1.56 as=0.1421 ps=1.56 w=0.49 l=0.2
X185 a_n1358_786# a_n1411_915# a_n1456_786# w_n6894_n2773# sky130_fd_pr__pfet_01v8 ad=0.1421 pd=1.56 as=0.1421 ps=1.56 w=0.49 l=0.2
X186 a_3942_1788# a_3889_1917# a_3844_1788# w_n6894_n2773# sky130_fd_pr__pfet_01v8 ad=0.1421 pd=1.56 as=0.1421 ps=1.56 w=0.49 l=0.2
X187 a_n2842_n216# a_n2895_n87# a_n2940_n216# w_n6894_n2773# sky130_fd_pr__pfet_01v8 ad=0.1421 pd=1.56 as=0.1421 ps=1.56 w=0.49 l=0.2
X188 a_n4962_n1552# a_n5015_n1423# a_n5060_n1552# w_n6894_n2773# sky130_fd_pr__pfet_01v8 ad=0.1421 pd=1.56 as=0.1421 ps=1.56 w=0.49 l=0.2
X189 a_n3478_2122# a_n3531_2251# a_n3576_2122# w_n6894_n2773# sky130_fd_pr__pfet_01v8 ad=0.1421 pd=1.56 as=0.1421 ps=1.56 w=0.49 l=0.2
X190 a_5850_n2220# a_5797_n2317# a_5752_n2220# w_n6894_n2773# sky130_fd_pr__pfet_01v8 ad=0.1421 pd=1.56 as=0.1421 ps=1.56 w=0.49 l=0.2
X191 a_n3266_n550# a_n3319_n647# a_n3364_n550# w_n6894_n2773# sky130_fd_pr__pfet_01v8 ad=0.1421 pd=1.56 as=0.1421 ps=1.56 w=0.49 l=0.2
X192 a_n2418_1454# a_n2471_1357# a_n2516_1454# w_n6894_n2773# sky130_fd_pr__pfet_01v8 ad=0.1421 pd=1.56 as=0.1421 ps=1.56 w=0.49 l=0.2
X193 a_n934_n216# a_n987_n313# a_n1032_n216# w_n6894_n2773# sky130_fd_pr__pfet_01v8 ad=0.1421 pd=1.56 as=0.1421 ps=1.56 w=0.49 l=0.2
X194 a_n6234_n1886# a_n6287_n1983# a_n6332_n1886# w_n6894_n2773# sky130_fd_pr__pfet_01v8 ad=0.1421 pd=1.56 as=0.1421 ps=1.56 w=0.49 l=0.2
X195 a_3306_2456# a_3253_2359# a_3208_2456# w_n6894_n2773# sky130_fd_pr__pfet_01v8 ad=0.1421 pd=1.56 as=0.1421 ps=1.56 w=0.49 l=0.2
X196 a_762_1454# a_709_1583# a_664_1454# w_n6894_n2773# sky130_fd_pr__pfet_01v8 ad=0.1421 pd=1.56 as=0.1421 ps=1.56 w=0.49 l=0.2
X197 a_126_118# a_73_21# a_28_118# w_n6894_n2773# sky130_fd_pr__pfet_01v8 ad=0.1421 pd=1.56 as=0.1421 ps=1.56 w=0.49 l=0.2
X198 a_6274_n1552# a_6221_n1649# a_6176_n1552# w_n6894_n2773# sky130_fd_pr__pfet_01v8 ad=0.1421 pd=1.56 as=0.1421 ps=1.56 w=0.49 l=0.2
X199 a_n4750_n216# a_n4803_n313# a_n4848_n216# w_n6894_n2773# sky130_fd_pr__pfet_01v8 ad=0.1421 pd=1.56 as=0.1421 ps=1.56 w=0.49 l=0.2
X200 a_6274_1788# a_6221_1691# a_6176_1788# w_n6894_n2773# sky130_fd_pr__pfet_01v8 ad=0.1421 pd=1.56 as=0.1421 ps=1.56 w=0.49 l=0.2
X201 a_n510_1454# a_n563_1583# a_n608_1454# w_n6894_n2773# sky130_fd_pr__pfet_01v8 ad=0.1421 pd=1.56 as=0.1421 ps=1.56 w=0.49 l=0.2
X202 a_4154_1120# a_4101_1023# a_4056_1120# w_n6894_n2773# sky130_fd_pr__pfet_01v8 ad=0.1421 pd=1.56 as=0.1421 ps=1.56 w=0.49 l=0.2
X203 a_1186_n2554# a_1133_n2425# a_1088_n2554# w_n6894_n2773# sky130_fd_pr__pfet_01v8 ad=0.1421 pd=1.56 as=0.1421 ps=1.56 w=0.49 l=0.2
X204 a_3306_n884# a_3253_n981# a_3208_n884# w_n6894_n2773# sky130_fd_pr__pfet_01v8 ad=0.1421 pd=1.56 as=0.1421 ps=1.56 w=0.49 l=0.2
X205 a_n3902_1120# a_n3955_1023# a_n4000_1120# w_n6894_n2773# sky130_fd_pr__pfet_01v8 ad=0.1421 pd=1.56 as=0.1421 ps=1.56 w=0.49 l=0.2
X206 a_n1358_n1218# a_n1411_n1089# a_n1456_n1218# w_n6894_n2773# sky130_fd_pr__pfet_01v8 ad=0.1421 pd=1.56 as=0.1421 ps=1.56 w=0.49 l=0.2
X207 a_4790_2122# a_4737_2025# a_4692_2122# w_n6894_n2773# sky130_fd_pr__pfet_01v8 ad=0.1421 pd=1.56 as=0.1421 ps=1.56 w=0.49 l=0.2
X208 a_2034_n1552# a_1981_n1649# a_1936_n1552# w_n6894_n2773# sky130_fd_pr__pfet_01v8 ad=0.1421 pd=1.56 as=0.1421 ps=1.56 w=0.49 l=0.2
X209 a_n6022_n1886# a_n6075_n1757# a_n6120_n1886# w_n6894_n2773# sky130_fd_pr__pfet_01v8 ad=0.1421 pd=1.56 as=0.1421 ps=1.56 w=0.49 l=0.2
X210 a_3730_1454# a_3677_1583# a_3632_1454# w_n6894_n2773# sky130_fd_pr__pfet_01v8 ad=0.1421 pd=1.56 as=0.1421 ps=1.56 w=0.49 l=0.2
X211 a_6062_n1552# a_6009_n1423# a_5964_n1552# w_n6894_n2773# sky130_fd_pr__pfet_01v8 ad=0.1421 pd=1.56 as=0.1421 ps=1.56 w=0.49 l=0.2
X212 a_1186_2456# a_1133_2359# a_1088_2456# w_n6894_n2773# sky130_fd_pr__pfet_01v8 ad=0.1421 pd=1.56 as=0.1421 ps=1.56 w=0.49 l=0.2
X213 a_n510_n2220# a_n563_n2317# a_n608_n2220# w_n6894_n2773# sky130_fd_pr__pfet_01v8 ad=0.1421 pd=1.56 as=0.1421 ps=1.56 w=0.49 l=0.2
X214 a_n2630_n216# a_n2683_n313# a_n2728_n216# w_n6894_n2773# sky130_fd_pr__pfet_01v8 ad=0.1421 pd=1.56 as=0.1421 ps=1.56 w=0.49 l=0.2
X215 a_4154_1788# a_4101_1691# a_4056_1788# w_n6894_n2773# sky130_fd_pr__pfet_01v8 ad=0.1421 pd=1.56 as=0.1421 ps=1.56 w=0.49 l=0.2
X216 a_n5810_1120# a_n5863_1249# a_n5908_1120# w_n6894_n2773# sky130_fd_pr__pfet_01v8 ad=0.1421 pd=1.56 as=0.1421 ps=1.56 w=0.49 l=0.2
X217 a_n2842_n2554# a_n2895_n2651# a_n2940_n2554# w_n6894_n2773# sky130_fd_pr__pfet_01v8 ad=0.1421 pd=1.56 as=0.1421 ps=1.56 w=0.49 l=0.2
X218 a_n3690_n1886# a_n3743_n1983# a_n3788_n1886# w_n6894_n2773# sky130_fd_pr__pfet_01v8 ad=0.1421 pd=1.56 as=0.1421 ps=1.56 w=0.49 l=0.2
X219 a_1186_n884# a_1133_n981# a_1088_n884# w_n6894_n2773# sky130_fd_pr__pfet_01v8 ad=0.1421 pd=1.56 as=0.1421 ps=1.56 w=0.49 l=0.2
X220 a_n3054_n216# a_n3107_n313# a_n3152_n216# w_n6894_n2773# sky130_fd_pr__pfet_01v8 ad=0.1421 pd=1.56 as=0.1421 ps=1.56 w=0.49 l=0.2
X221 a_974_n216# a_921_n87# a_876_n216# w_n6894_n2773# sky130_fd_pr__pfet_01v8 ad=0.1421 pd=1.56 as=0.1421 ps=1.56 w=0.49 l=0.2
X222 a_2458_n2220# a_2405_n2317# a_2360_n2220# w_n6894_n2773# sky130_fd_pr__pfet_01v8 ad=0.1421 pd=1.56 as=0.1421 ps=1.56 w=0.49 l=0.2
X223 a_6698_2122# a_6645_2251# a_6600_2122# w_n6894_n2773# sky130_fd_pr__pfet_01v8 ad=0.1421 pd=1.56 as=0.1421 ps=1.56 w=0.49 l=0.2
X224 a_n6234_1120# a_n6287_1249# a_n6332_1120# w_n6894_n2773# sky130_fd_pr__pfet_01v8 ad=0.1421 pd=1.56 as=0.1421 ps=1.56 w=0.49 l=0.2
X225 a_n3902_1788# a_n3955_1691# a_n4000_1788# w_n6894_n2773# sky130_fd_pr__pfet_01v8 ad=0.1421 pd=1.56 as=0.1421 ps=1.56 w=0.49 l=0.2
X226 a_n1782_1120# a_n1835_1023# a_n1880_1120# w_n6894_n2773# sky130_fd_pr__pfet_01v8 ad=0.1421 pd=1.56 as=0.1421 ps=1.56 w=0.49 l=0.2
X227 a_126_1120# a_73_1249# a_28_1120# w_n6894_n2773# sky130_fd_pr__pfet_01v8 ad=0.1421 pd=1.56 as=0.1421 ps=1.56 w=0.49 l=0.2
X228 a_6486_n550# a_6433_n647# a_6388_n550# w_n6894_n2773# sky130_fd_pr__pfet_01v8 ad=0.1421 pd=1.56 as=0.1421 ps=1.56 w=0.49 l=0.2
X229 a_n4750_n1552# a_n4803_n1649# a_n4848_n1552# w_n6894_n2773# sky130_fd_pr__pfet_01v8 ad=0.1421 pd=1.56 as=0.1421 ps=1.56 w=0.49 l=0.2
X230 a_n1146_n1218# a_n1199_n1315# a_n1244_n1218# w_n6894_n2773# sky130_fd_pr__pfet_01v8 ad=0.1421 pd=1.56 as=0.1421 ps=1.56 w=0.49 l=0.2
X231 a_5638_1454# a_5585_1357# a_5540_1454# w_n6894_n2773# sky130_fd_pr__pfet_01v8 ad=0.1421 pd=1.56 as=0.1421 ps=1.56 w=0.49 l=0.2
X232 a_2670_2122# a_2617_2025# a_2572_2122# w_n6894_n2773# sky130_fd_pr__pfet_01v8 ad=0.1421 pd=1.56 as=0.1421 ps=1.56 w=0.49 l=0.2
X233 a_n722_452# a_n775_581# a_n820_452# w_n6894_n2773# sky130_fd_pr__pfet_01v8 ad=0.1421 pd=1.56 as=0.1421 ps=1.56 w=0.49 l=0.2
X234 a_1822_n1552# a_1769_n1423# a_1724_n1552# w_n6894_n2773# sky130_fd_pr__pfet_01v8 ad=0.1421 pd=1.56 as=0.1421 ps=1.56 w=0.49 l=0.2
X235 a_n6022_118# a_n6075_247# a_n6120_118# w_n6894_n2773# sky130_fd_pr__pfet_01v8 ad=0.1421 pd=1.56 as=0.1421 ps=1.56 w=0.49 l=0.2
X236 a_1610_1454# a_1557_1583# a_1512_1454# w_n6894_n2773# sky130_fd_pr__pfet_01v8 ad=0.1421 pd=1.56 as=0.1421 ps=1.56 w=0.49 l=0.2
X237 a_n298_n2220# a_n351_n2091# a_n396_n2220# w_n6894_n2773# sky130_fd_pr__pfet_01v8 ad=0.1421 pd=1.56 as=0.1421 ps=1.56 w=0.49 l=0.2
X238 a_n3690_1120# a_n3743_1249# a_n3788_1120# w_n6894_n2773# sky130_fd_pr__pfet_01v8 ad=0.1421 pd=1.56 as=0.1421 ps=1.56 w=0.49 l=0.2
X239 a_n6446_118# a_n6499_247# a_n6544_118# w_n6894_n2773# sky130_fd_pr__pfet_01v8 ad=0.1421 pd=1.56 as=0.1421 ps=1.56 w=0.49 l=0.2
X240 a_n5810_1788# a_n5863_1917# a_n5908_1788# w_n6894_n2773# sky130_fd_pr__pfet_01v8 ad=0.1421 pd=1.56 as=0.1421 ps=1.56 w=0.49 l=0.2
X241 a_n3478_n1886# a_n3531_n1757# a_n3576_n1886# w_n6894_n2773# sky130_fd_pr__pfet_01v8 ad=0.1421 pd=1.56 as=0.1421 ps=1.56 w=0.49 l=0.2
X242 a_n934_786# a_n987_915# a_n1032_786# w_n6894_n2773# sky130_fd_pr__pfet_01v8 ad=0.1421 pd=1.56 as=0.1421 ps=1.56 w=0.49 l=0.2
X243 a_n4962_n216# a_n5015_n87# a_n5060_n216# w_n6894_n2773# sky130_fd_pr__pfet_01v8 ad=0.1421 pd=1.56 as=0.1421 ps=1.56 w=0.49 l=0.2
X244 a_2246_n2220# a_2193_n2091# a_2148_n2220# w_n6894_n2773# sky130_fd_pr__pfet_01v8 ad=0.1421 pd=1.56 as=0.1421 ps=1.56 w=0.49 l=0.2
X245 a_4578_2122# a_4525_2251# a_4480_2122# w_n6894_n2773# sky130_fd_pr__pfet_01v8 ad=0.1421 pd=1.56 as=0.1421 ps=1.56 w=0.49 l=0.2
X246 a_n6234_1788# a_n6287_1917# a_n6332_1788# w_n6894_n2773# sky130_fd_pr__pfet_01v8 ad=0.1421 pd=1.56 as=0.1421 ps=1.56 w=0.49 l=0.2
X247 a_n4114_1120# a_n4167_1249# a_n4212_1120# w_n6894_n2773# sky130_fd_pr__pfet_01v8 ad=0.1421 pd=1.56 as=0.1421 ps=1.56 w=0.49 l=0.2
X248 a_n1782_n1218# a_n1835_n1089# a_n1880_n1218# w_n6894_n2773# sky130_fd_pr__pfet_01v8 ad=0.1421 pd=1.56 as=0.1421 ps=1.56 w=0.49 l=0.2
X249 a_n1782_1788# a_n1835_1691# a_n1880_1788# w_n6894_n2773# sky130_fd_pr__pfet_01v8 ad=0.1421 pd=1.56 as=0.1421 ps=1.56 w=0.49 l=0.2
X250 a_126_1788# a_73_1917# a_28_1788# w_n6894_n2773# sky130_fd_pr__pfet_01v8 ad=0.1421 pd=1.56 as=0.1421 ps=1.56 w=0.49 l=0.2
X251 a_3518_1454# a_3465_1357# a_3420_1454# w_n6894_n2773# sky130_fd_pr__pfet_01v8 ad=0.1421 pd=1.56 as=0.1421 ps=1.56 w=0.49 l=0.2
X252 a_4366_n550# a_4313_n647# a_4268_n550# w_n6894_n2773# sky130_fd_pr__pfet_01v8 ad=0.1421 pd=1.56 as=0.1421 ps=1.56 w=0.49 l=0.2
X253 a_n4538_n1552# a_n4591_n1423# a_n4636_n1552# w_n6894_n2773# sky130_fd_pr__pfet_01v8 ad=0.1421 pd=1.56 as=0.1421 ps=1.56 w=0.49 l=0.2
X254 a_1610_n1552# a_1557_n1649# a_1512_n1552# w_n6894_n2773# sky130_fd_pr__pfet_01v8 ad=0.1421 pd=1.56 as=0.1421 ps=1.56 w=0.49 l=0.2
X255 a_338_n1886# a_285_n1757# a_240_n1886# w_n6894_n2773# sky130_fd_pr__pfet_01v8 ad=0.1421 pd=1.56 as=0.1421 ps=1.56 w=0.49 l=0.2
X256 a_n86_n2220# a_n139_n2317# a_n184_n2220# w_n6894_n2773# sky130_fd_pr__pfet_01v8 ad=0.1421 pd=1.56 as=0.1421 ps=1.56 w=0.49 l=0.2
X257 a_n5174_2456# a_n5227_2359# a_n5272_2456# w_n6894_n2773# sky130_fd_pr__pfet_01v8 ad=0.1421 pd=1.56 as=0.1421 ps=1.56 w=0.49 l=0.2
X258 a_n1570_1120# a_n1623_1249# a_n1668_1120# w_n6894_n2773# sky130_fd_pr__pfet_01v8 ad=0.1421 pd=1.56 as=0.1421 ps=1.56 w=0.49 l=0.2
X259 a_n1146_2456# a_n1199_2585# a_n1244_2456# w_n6894_n2773# sky130_fd_pr__pfet_01v8 ad=0.1421 pd=1.56 as=0.1421 ps=1.56 w=0.49 l=0.2
X260 a_n3690_1788# a_n3743_1917# a_n3788_1788# w_n6894_n2773# sky130_fd_pr__pfet_01v8 ad=0.1421 pd=1.56 as=0.1421 ps=1.56 w=0.49 l=0.2
X261 a_338_1120# a_285_1023# a_240_1120# w_n6894_n2773# sky130_fd_pr__pfet_01v8 ad=0.1421 pd=1.56 as=0.1421 ps=1.56 w=0.49 l=0.2
X262 a_n298_452# a_n351_581# a_n396_452# w_n6894_n2773# sky130_fd_pr__pfet_01v8 ad=0.1421 pd=1.56 as=0.1421 ps=1.56 w=0.49 l=0.2
X263 a_1822_n216# a_1769_n87# a_1724_n216# w_n6894_n2773# sky130_fd_pr__pfet_01v8 ad=0.1421 pd=1.56 as=0.1421 ps=1.56 w=0.49 l=0.2
X264 a_5850_n216# a_5797_n313# a_5752_n216# w_n6894_n2773# sky130_fd_pr__pfet_01v8 ad=0.1421 pd=1.56 as=0.1421 ps=1.56 w=0.49 l=0.2
X265 a_n3266_n1886# a_n3319_n1983# a_n3364_n1886# w_n6894_n2773# sky130_fd_pr__pfet_01v8 ad=0.1421 pd=1.56 as=0.1421 ps=1.56 w=0.49 l=0.2
X266 a_5002_1120# a_4949_1023# a_4904_1120# w_n6894_n2773# sky130_fd_pr__pfet_01v8 ad=0.1421 pd=1.56 as=0.1421 ps=1.56 w=0.49 l=0.2
X267 a_n3902_n2220# a_n3955_n2317# a_n4000_n2220# w_n6894_n2773# sky130_fd_pr__pfet_01v8 ad=0.1421 pd=1.56 as=0.1421 ps=1.56 w=0.49 l=0.2
X268 a_2458_2122# a_2405_2251# a_2360_2122# w_n6894_n2773# sky130_fd_pr__pfet_01v8 ad=0.1421 pd=1.56 as=0.1421 ps=1.56 w=0.49 l=0.2
X269 a_n4114_1788# a_n4167_1917# a_n4212_1788# w_n6894_n2773# sky130_fd_pr__pfet_01v8 ad=0.1421 pd=1.56 as=0.1421 ps=1.56 w=0.49 l=0.2
X270 a_n1994_1120# a_n2047_1249# a_n2092_1120# w_n6894_n2773# sky130_fd_pr__pfet_01v8 ad=0.1421 pd=1.56 as=0.1421 ps=1.56 w=0.49 l=0.2
X271 a_n1146_n884# a_n1199_n755# a_n1244_n884# w_n6894_n2773# sky130_fd_pr__pfet_01v8 ad=0.1421 pd=1.56 as=0.1421 ps=1.56 w=0.49 l=0.2
X272 a_n5174_n884# a_n5227_n981# a_n5272_n884# w_n6894_n2773# sky130_fd_pr__pfet_01v8 ad=0.1421 pd=1.56 as=0.1421 ps=1.56 w=0.49 l=0.2
X273 a_n6658_2122# a_n6711_2025# a_n6756_2122# w_n6894_n2773# sky130_fd_pr__pfet_01v8 ad=0.1421 pd=1.56 as=0.1421 ps=1.56 w=0.49 l=0.2
X274 a_2246_n550# a_2193_n647# a_2148_n550# w_n6894_n2773# sky130_fd_pr__pfet_01v8 ad=0.1421 pd=1.56 as=0.1421 ps=1.56 w=0.49 l=0.2
X275 a_n6658_n2554# a_n6711_n2651# a_n6756_n2554# w_n6894_n2773# sky130_fd_pr__pfet_01v8 ad=0.1421 pd=1.56 as=0.1421 ps=1.56 w=0.49 l=0.2
X276 a_n3054_n2220# a_n3107_n2317# a_n3152_n2220# w_n6894_n2773# sky130_fd_pr__pfet_01v8 ad=0.1421 pd=1.56 as=0.1421 ps=1.56 w=0.49 l=0.2
X277 a_1398_1454# a_1345_1357# a_1300_1454# w_n6894_n2773# sky130_fd_pr__pfet_01v8 ad=0.1421 pd=1.56 as=0.1421 ps=1.56 w=0.49 l=0.2
X278 a_n86_786# a_n139_915# a_n184_786# w_n6894_n2773# sky130_fd_pr__pfet_01v8 ad=0.1421 pd=1.56 as=0.1421 ps=1.56 w=0.49 l=0.2
X279 a_n4326_n1552# a_n4379_n1649# a_n4424_n1552# w_n6894_n2773# sky130_fd_pr__pfet_01v8 ad=0.1421 pd=1.56 as=0.1421 ps=1.56 w=0.49 l=0.2
X280 a_n934_n1218# a_n987_n1089# a_n1032_n1218# w_n6894_n2773# sky130_fd_pr__pfet_01v8 ad=0.1421 pd=1.56 as=0.1421 ps=1.56 w=0.49 l=0.2
X281 a_n6446_n550# a_n6499_n421# a_n6544_n550# w_n6894_n2773# sky130_fd_pr__pfet_01v8 ad=0.1421 pd=1.56 as=0.1421 ps=1.56 w=0.49 l=0.2
X282 a_3730_n2554# a_3677_n2425# a_3632_n2554# w_n6894_n2773# sky130_fd_pr__pfet_01v8 ad=0.1421 pd=1.56 as=0.1421 ps=1.56 w=0.49 l=0.2
X283 a_n5810_n1218# a_n5863_n1315# a_n5908_n1218# w_n6894_n2773# sky130_fd_pr__pfet_01v8 ad=0.1421 pd=1.56 as=0.1421 ps=1.56 w=0.49 l=0.2
X284 a_n86_1120# a_n139_1023# a_n184_1120# w_n6894_n2773# sky130_fd_pr__pfet_01v8 ad=0.1421 pd=1.56 as=0.1421 ps=1.56 w=0.49 l=0.2
X285 a_5850_118# a_5797_247# a_5752_118# w_n6894_n2773# sky130_fd_pr__pfet_01v8 ad=0.1421 pd=1.56 as=0.1421 ps=1.56 w=0.49 l=0.2
X286 a_4578_n1886# a_4525_n1757# a_4480_n1886# w_n6894_n2773# sky130_fd_pr__pfet_01v8 ad=0.1421 pd=1.56 as=0.1421 ps=1.56 w=0.49 l=0.2
X287 a_974_n1886# a_921_n1983# a_876_n1886# w_n6894_n2773# sky130_fd_pr__pfet_01v8 ad=0.1421 pd=1.56 as=0.1421 ps=1.56 w=0.49 l=0.2
X288 a_n510_786# a_n563_915# a_n608_786# w_n6894_n2773# sky130_fd_pr__pfet_01v8 ad=0.1421 pd=1.56 as=0.1421 ps=1.56 w=0.49 l=0.2
X289 a_2882_n1218# a_2829_n1089# a_2784_n1218# w_n6894_n2773# sky130_fd_pr__pfet_01v8 ad=0.1421 pd=1.56 as=0.1421 ps=1.56 w=0.49 l=0.2
X290 a_5638_n1552# a_5585_n1423# a_5540_n1552# w_n6894_n2773# sky130_fd_pr__pfet_01v8 ad=0.1421 pd=1.56 as=0.1421 ps=1.56 w=0.49 l=0.2
X291 a_2034_2456# a_1981_2359# a_1936_2456# w_n6894_n2773# sky130_fd_pr__pfet_01v8 ad=0.1421 pd=1.56 as=0.1421 ps=1.56 w=0.49 l=0.2
X292 a_n722_2122# a_n775_2025# a_n820_2122# w_n6894_n2773# sky130_fd_pr__pfet_01v8 ad=0.1421 pd=1.56 as=0.1421 ps=1.56 w=0.49 l=0.2
X293 a_n1570_1788# a_n1623_1917# a_n1668_1788# w_n6894_n2773# sky130_fd_pr__pfet_01v8 ad=0.1421 pd=1.56 as=0.1421 ps=1.56 w=0.49 l=0.2
X294 a_338_1788# a_285_1691# a_240_1788# w_n6894_n2773# sky130_fd_pr__pfet_01v8 ad=0.1421 pd=1.56 as=0.1421 ps=1.56 w=0.49 l=0.2
X295 a_5002_1788# a_4949_1691# a_4904_1788# w_n6894_n2773# sky130_fd_pr__pfet_01v8 ad=0.1421 pd=1.56 as=0.1421 ps=1.56 w=0.49 l=0.2
X296 a_2882_1120# a_2829_1023# a_2784_1120# w_n6894_n2773# sky130_fd_pr__pfet_01v8 ad=0.1421 pd=1.56 as=0.1421 ps=1.56 w=0.49 l=0.2
X297 a_2034_n884# a_1981_n981# a_1936_n884# w_n6894_n2773# sky130_fd_pr__pfet_01v8 ad=0.1421 pd=1.56 as=0.1421 ps=1.56 w=0.49 l=0.2
X298 a_n1994_1788# a_n2047_1917# a_n2092_1788# w_n6894_n2773# sky130_fd_pr__pfet_01v8 ad=0.1421 pd=1.56 as=0.1421 ps=1.56 w=0.49 l=0.2
X299 a_n4538_2122# a_n4591_2025# a_n4636_2122# w_n6894_n2773# sky130_fd_pr__pfet_01v8 ad=0.1421 pd=1.56 as=0.1421 ps=1.56 w=0.49 l=0.2
X300 a_n6446_n2554# a_n6499_n2425# a_n6544_n2554# w_n6894_n2773# sky130_fd_pr__pfet_01v8 ad=0.1421 pd=1.56 as=0.1421 ps=1.56 w=0.49 l=0.2
X301 a_n4114_n1552# a_n4167_n1423# a_n4212_n1552# w_n6894_n2773# sky130_fd_pr__pfet_01v8 ad=0.1421 pd=1.56 as=0.1421 ps=1.56 w=0.49 l=0.2
X302 a_n722_n1218# a_n775_n1315# a_n820_n1218# w_n6894_n2773# sky130_fd_pr__pfet_01v8 ad=0.1421 pd=1.56 as=0.1421 ps=1.56 w=0.49 l=0.2
X303 a_5002_118# a_4949_247# a_4904_118# w_n6894_n2773# sky130_fd_pr__pfet_01v8 ad=0.1421 pd=1.56 as=0.1421 ps=1.56 w=0.49 l=0.2
X304 a_n4326_n550# a_n4379_n421# a_n4424_n550# w_n6894_n2773# sky130_fd_pr__pfet_01v8 ad=0.1421 pd=1.56 as=0.1421 ps=1.56 w=0.49 l=0.2
X305 a_762_n1886# a_709_n1757# a_664_n1886# w_n6894_n2773# sky130_fd_pr__pfet_01v8 ad=0.1421 pd=1.56 as=0.1421 ps=1.56 w=0.49 l=0.2
X306 a_n5598_n1218# a_n5651_n1089# a_n5696_n1218# w_n6894_n2773# sky130_fd_pr__pfet_01v8 ad=0.1421 pd=1.56 as=0.1421 ps=1.56 w=0.49 l=0.2
X307 a_n86_1788# a_n139_1691# a_n184_1788# w_n6894_n2773# sky130_fd_pr__pfet_01v8 ad=0.1421 pd=1.56 as=0.1421 ps=1.56 w=0.49 l=0.2
X308 a_n2842_118# a_n2895_21# a_n2940_118# w_n6894_n2773# sky130_fd_pr__pfet_01v8 ad=0.1421 pd=1.56 as=0.1421 ps=1.56 w=0.49 l=0.2
X309 a_4366_n1886# a_4313_n1983# a_4268_n1886# w_n6894_n2773# sky130_fd_pr__pfet_01v8 ad=0.1421 pd=1.56 as=0.1421 ps=1.56 w=0.49 l=0.2
X310 a_5002_n2220# a_4949_n2317# a_4904_n2220# w_n6894_n2773# sky130_fd_pr__pfet_01v8 ad=0.1421 pd=1.56 as=0.1421 ps=1.56 w=0.49 l=0.2
X311 a_2670_n1218# a_2617_n1315# a_2572_n1218# w_n6894_n2773# sky130_fd_pr__pfet_01v8 ad=0.1421 pd=1.56 as=0.1421 ps=1.56 w=0.49 l=0.2
X312 a_6062_n216# a_6009_n87# a_5964_n216# w_n6894_n2773# sky130_fd_pr__pfet_01v8 ad=0.1421 pd=1.56 as=0.1421 ps=1.56 w=0.49 l=0.2
X313 a_3942_2456# a_3889_2585# a_3844_2456# w_n6894_n2773# sky130_fd_pr__pfet_01v8 ad=0.1421 pd=1.56 as=0.1421 ps=1.56 w=0.49 l=0.2
X314 a_5214_1120# a_5161_1249# a_5116_1120# w_n6894_n2773# sky130_fd_pr__pfet_01v8 ad=0.1421 pd=1.56 as=0.1421 ps=1.56 w=0.49 l=0.2
X315 a_5426_n1552# a_5373_n1649# a_5328_n1552# w_n6894_n2773# sky130_fd_pr__pfet_01v8 ad=0.1421 pd=1.56 as=0.1421 ps=1.56 w=0.49 l=0.2
X316 a_2882_1788# a_2829_1691# a_2784_1788# w_n6894_n2773# sky130_fd_pr__pfet_01v8 ad=0.1421 pd=1.56 as=0.1421 ps=1.56 w=0.49 l=0.2
X317 a_n3266_118# a_n3319_21# a_n3364_118# w_n6894_n2773# sky130_fd_pr__pfet_01v8 ad=0.1421 pd=1.56 as=0.1421 ps=1.56 w=0.49 l=0.2
X318 a_3942_n884# a_3889_n755# a_3844_n884# w_n6894_n2773# sky130_fd_pr__pfet_01v8 ad=0.1421 pd=1.56 as=0.1421 ps=1.56 w=0.49 l=0.2
X319 a_3730_118# a_3677_247# a_3632_118# w_n6894_n2773# sky130_fd_pr__pfet_01v8 ad=0.1421 pd=1.56 as=0.1421 ps=1.56 w=0.49 l=0.2
X320 a_n2418_2122# a_n2471_2025# a_n2516_2122# w_n6894_n2773# sky130_fd_pr__pfet_01v8 ad=0.1421 pd=1.56 as=0.1421 ps=1.56 w=0.49 l=0.2
X321 a_n6234_n2554# a_n6287_n2651# a_n6332_n2554# w_n6894_n2773# sky130_fd_pr__pfet_01v8 ad=0.1421 pd=1.56 as=0.1421 ps=1.56 w=0.49 l=0.2
X322 a_n3690_118# a_n3743_21# a_n3788_118# w_n6894_n2773# sky130_fd_pr__pfet_01v8 ad=0.1421 pd=1.56 as=0.1421 ps=1.56 w=0.49 l=0.2
X323 a_n2206_n550# a_n2259_n421# a_n2304_n550# w_n6894_n2773# sky130_fd_pr__pfet_01v8 ad=0.1421 pd=1.56 as=0.1421 ps=1.56 w=0.49 l=0.2
X324 a_550_n1886# a_497_n1983# a_452_n1886# w_n6894_n2773# sky130_fd_pr__pfet_01v8 ad=0.1421 pd=1.56 as=0.1421 ps=1.56 w=0.49 l=0.2
X325 a_n5386_n1218# a_n5439_n1315# a_n5484_n1218# w_n6894_n2773# sky130_fd_pr__pfet_01v8 ad=0.1421 pd=1.56 as=0.1421 ps=1.56 w=0.49 l=0.2
X326 a_762_2122# a_709_2251# a_664_2122# w_n6894_n2773# sky130_fd_pr__pfet_01v8 ad=0.1421 pd=1.56 as=0.1421 ps=1.56 w=0.49 l=0.2
X327 a_n5386_1454# a_n5439_1357# a_n5484_1454# w_n6894_n2773# sky130_fd_pr__pfet_01v8 ad=0.1421 pd=1.56 as=0.1421 ps=1.56 w=0.49 l=0.2
X328 a_n1358_1454# a_n1411_1583# a_n1456_1454# w_n6894_n2773# sky130_fd_pr__pfet_01v8 ad=0.1421 pd=1.56 as=0.1421 ps=1.56 w=0.49 l=0.2
X329 a_n5174_452# a_n5227_355# a_n5272_452# w_n6894_n2773# sky130_fd_pr__pfet_01v8 ad=0.1421 pd=1.56 as=0.1421 ps=1.56 w=0.49 l=0.2
X330 a_4790_n2220# a_4737_n2091# a_4692_n2220# w_n6894_n2773# sky130_fd_pr__pfet_01v8 ad=0.1421 pd=1.56 as=0.1421 ps=1.56 w=0.49 l=0.2
X331 a_4154_n1886# a_4101_n1757# a_4056_n1886# w_n6894_n2773# sky130_fd_pr__pfet_01v8 ad=0.1421 pd=1.56 as=0.1421 ps=1.56 w=0.49 l=0.2
X332 a_n510_2122# a_n563_2251# a_n608_2122# w_n6894_n2773# sky130_fd_pr__pfet_01v8 ad=0.1421 pd=1.56 as=0.1421 ps=1.56 w=0.49 l=0.2
X333 a_126_n1218# a_73_n1315# a_28_n1218# w_n6894_n2773# sky130_fd_pr__pfet_01v8 ad=0.1421 pd=1.56 as=0.1421 ps=1.56 w=0.49 l=0.2
X334 a_6274_2456# a_6221_2359# a_6176_2456# w_n6894_n2773# sky130_fd_pr__pfet_01v8 ad=0.1421 pd=1.56 as=0.1421 ps=1.56 w=0.49 l=0.2
X335 a_550_n550# a_497_n647# a_452_n550# w_n6894_n2773# sky130_fd_pr__pfet_01v8 ad=0.1421 pd=1.56 as=0.1421 ps=1.56 w=0.49 l=0.2
X336 a_n5598_452# a_n5651_355# a_n5696_452# w_n6894_n2773# sky130_fd_pr__pfet_01v8 ad=0.1421 pd=1.56 as=0.1421 ps=1.56 w=0.49 l=0.2
X337 a_n1994_118# a_n2047_21# a_n2092_118# w_n6894_n2773# sky130_fd_pr__pfet_01v8 ad=0.1421 pd=1.56 as=0.1421 ps=1.56 w=0.49 l=0.2
X338 a_4154_118# a_4101_247# a_4056_118# w_n6894_n2773# sky130_fd_pr__pfet_01v8 ad=0.1421 pd=1.56 as=0.1421 ps=1.56 w=0.49 l=0.2
X339 a_n298_n550# a_n351_n647# a_n396_n550# w_n6894_n2773# sky130_fd_pr__pfet_01v8 ad=0.1421 pd=1.56 as=0.1421 ps=1.56 w=0.49 l=0.2
X340 a_n1570_n1552# a_n1623_n1423# a_n1668_n1552# w_n6894_n2773# sky130_fd_pr__pfet_01v8 ad=0.1421 pd=1.56 as=0.1421 ps=1.56 w=0.49 l=0.2
X341 a_3094_1120# a_3041_1249# a_2996_1120# w_n6894_n2773# sky130_fd_pr__pfet_01v8 ad=0.1421 pd=1.56 as=0.1421 ps=1.56 w=0.49 l=0.2
X342 a_338_118# a_285_247# a_240_118# w_n6894_n2773# sky130_fd_pr__pfet_01v8 ad=0.1421 pd=1.56 as=0.1421 ps=1.56 w=0.49 l=0.2
X343 a_5214_n1552# a_5161_n1423# a_5116_n1552# w_n6894_n2773# sky130_fd_pr__pfet_01v8 ad=0.1421 pd=1.56 as=0.1421 ps=1.56 w=0.49 l=0.2
X344 a_6274_n884# a_6221_n981# a_6176_n884# w_n6894_n2773# sky130_fd_pr__pfet_01v8 ad=0.1421 pd=1.56 as=0.1421 ps=1.56 w=0.49 l=0.2
X345 a_5214_1788# a_5161_1917# a_5116_1788# w_n6894_n2773# sky130_fd_pr__pfet_01v8 ad=0.1421 pd=1.56 as=0.1421 ps=1.56 w=0.49 l=0.2
X346 a_n4962_786# a_n5015_689# a_n5060_786# w_n6894_n2773# sky130_fd_pr__pfet_01v8 ad=0.1421 pd=1.56 as=0.1421 ps=1.56 w=0.49 l=0.2
X347 a_4578_118# a_4525_247# a_4480_118# w_n6894_n2773# sky130_fd_pr__pfet_01v8 ad=0.1421 pd=1.56 as=0.1421 ps=1.56 w=0.49 l=0.2
X348 a_6698_n1218# a_6645_n1089# a_6600_n1218# w_n6894_n2773# sky130_fd_pr__pfet_01v8 ad=0.1421 pd=1.56 as=0.1421 ps=1.56 w=0.49 l=0.2
X349 a_n2418_118# a_n2471_21# a_n2516_118# w_n6894_n2773# sky130_fd_pr__pfet_01v8 ad=0.1421 pd=1.56 as=0.1421 ps=1.56 w=0.49 l=0.2
X350 a_n2842_1120# a_n2895_1249# a_n2940_1120# w_n6894_n2773# sky130_fd_pr__pfet_01v8 ad=0.1421 pd=1.56 as=0.1421 ps=1.56 w=0.49 l=0.2
X351 a_n5386_786# a_n5439_689# a_n5484_786# w_n6894_n2773# sky130_fd_pr__pfet_01v8 ad=0.1421 pd=1.56 as=0.1421 ps=1.56 w=0.49 l=0.2
X352 a_6062_452# a_6009_581# a_5964_452# w_n6894_n2773# sky130_fd_pr__pfet_01v8 ad=0.1421 pd=1.56 as=0.1421 ps=1.56 w=0.49 l=0.2
X353 a_n6022_n2554# a_n6075_n2425# a_n6120_n2554# w_n6894_n2773# sky130_fd_pr__pfet_01v8 ad=0.1421 pd=1.56 as=0.1421 ps=1.56 w=0.49 l=0.2
X354 a_n5810_786# a_n5863_689# a_n5908_786# w_n6894_n2773# sky130_fd_pr__pfet_01v8 ad=0.1421 pd=1.56 as=0.1421 ps=1.56 w=0.49 l=0.2
X355 a_6486_452# a_6433_581# a_6388_452# w_n6894_n2773# sky130_fd_pr__pfet_01v8 ad=0.1421 pd=1.56 as=0.1421 ps=1.56 w=0.49 l=0.2
X356 a_3730_2122# a_3677_2251# a_3632_2122# w_n6894_n2773# sky130_fd_pr__pfet_01v8 ad=0.1421 pd=1.56 as=0.1421 ps=1.56 w=0.49 l=0.2
X357 a_n4326_452# a_n4379_355# a_n4424_452# w_n6894_n2773# sky130_fd_pr__pfet_01v8 ad=0.1421 pd=1.56 as=0.1421 ps=1.56 w=0.49 l=0.2
X358 a_n5174_n1218# a_n5227_n1089# a_n5272_n1218# w_n6894_n2773# sky130_fd_pr__pfet_01v8 ad=0.1421 pd=1.56 as=0.1421 ps=1.56 w=0.49 l=0.2
X359 a_n3266_1454# a_n3319_1357# a_n3364_1454# w_n6894_n2773# sky130_fd_pr__pfet_01v8 ad=0.1421 pd=1.56 as=0.1421 ps=1.56 w=0.49 l=0.2
X360 a_n934_1120# a_n987_1023# a_n1032_1120# w_n6894_n2773# sky130_fd_pr__pfet_01v8 ad=0.1421 pd=1.56 as=0.1421 ps=1.56 w=0.49 l=0.2
X361 a_3306_118# a_3253_247# a_3208_118# w_n6894_n2773# sky130_fd_pr__pfet_01v8 ad=0.1421 pd=1.56 as=0.1421 ps=1.56 w=0.49 l=0.2
X362 a_5850_n1552# a_5797_n1649# a_5752_n1552# w_n6894_n2773# sky130_fd_pr__pfet_01v8 ad=0.1421 pd=1.56 as=0.1421 ps=1.56 w=0.49 l=0.2
X363 a_4154_2456# a_4101_2359# a_4056_2456# w_n6894_n2773# sky130_fd_pr__pfet_01v8 ad=0.1421 pd=1.56 as=0.1421 ps=1.56 w=0.49 l=0.2
X364 a_n4750_452# a_n4803_355# a_n4848_452# w_n6894_n2773# sky130_fd_pr__pfet_01v8 ad=0.1421 pd=1.56 as=0.1421 ps=1.56 w=0.49 l=0.2
X365 a_n1146_118# a_n1199_21# a_n1244_118# w_n6894_n2773# sky130_fd_pr__pfet_01v8 ad=0.1421 pd=1.56 as=0.1421 ps=1.56 w=0.49 l=0.2
X366 a_n3690_n2554# a_n3743_n2651# a_n3788_n2554# w_n6894_n2773# sky130_fd_pr__pfet_01v8 ad=0.1421 pd=1.56 as=0.1421 ps=1.56 w=0.49 l=0.2
X367 a_6274_786# a_6221_915# a_6176_786# w_n6894_n2773# sky130_fd_pr__pfet_01v8 ad=0.1421 pd=1.56 as=0.1421 ps=1.56 w=0.49 l=0.2
X368 a_n5598_n216# a_n5651_n313# a_n5696_n216# w_n6894_n2773# sky130_fd_pr__pfet_01v8 ad=0.1421 pd=1.56 as=0.1421 ps=1.56 w=0.49 l=0.2
X369 a_n4750_1120# a_n4803_1023# a_n4848_1120# w_n6894_n2773# sky130_fd_pr__pfet_01v8 ad=0.1421 pd=1.56 as=0.1421 ps=1.56 w=0.49 l=0.2
X370 a_n4114_786# a_n4167_689# a_n4212_786# w_n6894_n2773# sky130_fd_pr__pfet_01v8 ad=0.1421 pd=1.56 as=0.1421 ps=1.56 w=0.49 l=0.2
X371 a_4154_n884# a_4101_n981# a_4056_n884# w_n6894_n2773# sky130_fd_pr__pfet_01v8 ad=0.1421 pd=1.56 as=0.1421 ps=1.56 w=0.49 l=0.2
X372 a_3094_1788# a_3041_1917# a_2996_1788# w_n6894_n2773# sky130_fd_pr__pfet_01v8 ad=0.1421 pd=1.56 as=0.1421 ps=1.56 w=0.49 l=0.2
X373 a_n6022_n216# a_n6075_n313# a_n6120_n216# w_n6894_n2773# sky130_fd_pr__pfet_01v8 ad=0.1421 pd=1.56 as=0.1421 ps=1.56 w=0.49 l=0.2
X374 a_6486_n1218# a_6433_n1315# a_6388_n1218# w_n6894_n2773# sky130_fd_pr__pfet_01v8 ad=0.1421 pd=1.56 as=0.1421 ps=1.56 w=0.49 l=0.2
X375 a_n3902_2456# a_n3955_2359# a_n4000_2456# w_n6894_n2773# sky130_fd_pr__pfet_01v8 ad=0.1421 pd=1.56 as=0.1421 ps=1.56 w=0.49 l=0.2
X376 a_5638_2122# a_5585_2025# a_5540_2122# w_n6894_n2773# sky130_fd_pr__pfet_01v8 ad=0.1421 pd=1.56 as=0.1421 ps=1.56 w=0.49 l=0.2
X377 a_6698_786# a_6645_915# a_6600_786# w_n6894_n2773# sky130_fd_pr__pfet_01v8 ad=0.1421 pd=1.56 as=0.1421 ps=1.56 w=0.49 l=0.2
X378 a_n4538_786# a_n4591_689# a_n4636_786# w_n6894_n2773# sky130_fd_pr__pfet_01v8 ad=0.1421 pd=1.56 as=0.1421 ps=1.56 w=0.49 l=0.2
X379 a_5214_452# a_5161_581# a_5116_452# w_n6894_n2773# sky130_fd_pr__pfet_01v8 ad=0.1421 pd=1.56 as=0.1421 ps=1.56 w=0.49 l=0.2
X380 a_n2630_n1886# a_n2683_n1757# a_n2728_n1886# w_n6894_n2773# sky130_fd_pr__pfet_01v8 ad=0.1421 pd=1.56 as=0.1421 ps=1.56 w=0.49 l=0.2
X381 a_n3054_452# a_n3107_355# a_n3152_452# w_n6894_n2773# sky130_fd_pr__pfet_01v8 ad=0.1421 pd=1.56 as=0.1421 ps=1.56 w=0.49 l=0.2
X382 a_5426_n550# a_5373_n421# a_5328_n550# w_n6894_n2773# sky130_fd_pr__pfet_01v8 ad=0.1421 pd=1.56 as=0.1421 ps=1.56 w=0.49 l=0.2
X383 a_1398_n2220# a_1345_n2091# a_1300_n2220# w_n6894_n2773# sky130_fd_pr__pfet_01v8 ad=0.1421 pd=1.56 as=0.1421 ps=1.56 w=0.49 l=0.2
X384 a_n3902_n884# a_n3955_n981# a_n4000_n884# w_n6894_n2773# sky130_fd_pr__pfet_01v8 ad=0.1421 pd=1.56 as=0.1421 ps=1.56 w=0.49 l=0.2
X385 a_n2842_1788# a_n2895_1917# a_n2940_1788# w_n6894_n2773# sky130_fd_pr__pfet_01v8 ad=0.1421 pd=1.56 as=0.1421 ps=1.56 w=0.49 l=0.2
X386 a_5638_452# a_5585_581# a_5540_452# w_n6894_n2773# sky130_fd_pr__pfet_01v8 ad=0.1421 pd=1.56 as=0.1421 ps=1.56 w=0.49 l=0.2
X387 a_1610_2122# a_1557_2251# a_1512_2122# w_n6894_n2773# sky130_fd_pr__pfet_01v8 ad=0.1421 pd=1.56 as=0.1421 ps=1.56 w=0.49 l=0.2
X388 a_762_452# a_709_355# a_664_452# w_n6894_n2773# sky130_fd_pr__pfet_01v8 ad=0.1421 pd=1.56 as=0.1421 ps=1.56 w=0.49 l=0.2
X389 a_n4962_n1218# a_n5015_n1315# a_n5060_n1218# w_n6894_n2773# sky130_fd_pr__pfet_01v8 ad=0.1421 pd=1.56 as=0.1421 ps=1.56 w=0.49 l=0.2
X390 a_n5810_2456# a_n5863_2585# a_n5908_2456# w_n6894_n2773# sky130_fd_pr__pfet_01v8 ad=0.1421 pd=1.56 as=0.1421 ps=1.56 w=0.49 l=0.2
X391 a_n934_1788# a_n987_1691# a_n1032_1788# w_n6894_n2773# sky130_fd_pr__pfet_01v8 ad=0.1421 pd=1.56 as=0.1421 ps=1.56 w=0.49 l=0.2
X392 a_5426_786# a_5373_915# a_5328_786# w_n6894_n2773# sky130_fd_pr__pfet_01v8 ad=0.1421 pd=1.56 as=0.1421 ps=1.56 w=0.49 l=0.2
X393 a_n3478_n2554# a_n3531_n2425# a_n3576_n2554# w_n6894_n2773# sky130_fd_pr__pfet_01v8 ad=0.1421 pd=1.56 as=0.1421 ps=1.56 w=0.49 l=0.2
X394 a_n6234_2456# a_n6287_2585# a_n6332_2456# w_n6894_n2773# sky130_fd_pr__pfet_01v8 ad=0.1421 pd=1.56 as=0.1421 ps=1.56 w=0.49 l=0.2
X395 a_550_786# a_497_689# a_452_786# w_n6894_n2773# sky130_fd_pr__pfet_01v8 ad=0.1421 pd=1.56 as=0.1421 ps=1.56 w=0.49 l=0.2
X396 a_n3478_n216# a_n3531_n313# a_n3576_n216# w_n6894_n2773# sky130_fd_pr__pfet_01v8 ad=0.1421 pd=1.56 as=0.1421 ps=1.56 w=0.49 l=0.2
X397 a_n5810_n884# a_n5863_n755# a_n5908_n884# w_n6894_n2773# sky130_fd_pr__pfet_01v8 ad=0.1421 pd=1.56 as=0.1421 ps=1.56 w=0.49 l=0.2
X398 a_n4750_1788# a_n4803_1691# a_n4848_1788# w_n6894_n2773# sky130_fd_pr__pfet_01v8 ad=0.1421 pd=1.56 as=0.1421 ps=1.56 w=0.49 l=0.2
X399 a_n2630_1120# a_n2683_1023# a_n2728_1120# w_n6894_n2773# sky130_fd_pr__pfet_01v8 ad=0.1421 pd=1.56 as=0.1421 ps=1.56 w=0.49 l=0.2
X400 a_126_2456# a_73_2585# a_28_2456# w_n6894_n2773# sky130_fd_pr__pfet_01v8 ad=0.1421 pd=1.56 as=0.1421 ps=1.56 w=0.49 l=0.2
X401 a_974_786# a_921_689# a_876_786# w_n6894_n2773# sky130_fd_pr__pfet_01v8 ad=0.1421 pd=1.56 as=0.1421 ps=1.56 w=0.49 l=0.2
X402 a_n510_n1552# a_n563_n1649# a_n608_n1552# w_n6894_n2773# sky130_fd_pr__pfet_01v8 ad=0.1421 pd=1.56 as=0.1421 ps=1.56 w=0.49 l=0.2
X403 a_6274_n1218# a_6221_n1089# a_6176_n1218# w_n6894_n2773# sky130_fd_pr__pfet_01v8 ad=0.1421 pd=1.56 as=0.1421 ps=1.56 w=0.49 l=0.2
X404 a_n1782_2456# a_n1835_2359# a_n1880_2456# w_n6894_n2773# sky130_fd_pr__pfet_01v8 ad=0.1421 pd=1.56 as=0.1421 ps=1.56 w=0.49 l=0.2
X405 a_3518_2122# a_3465_2025# a_3420_2122# w_n6894_n2773# sky130_fd_pr__pfet_01v8 ad=0.1421 pd=1.56 as=0.1421 ps=1.56 w=0.49 l=0.2
X406 a_n3054_1120# a_n3107_1023# a_n3152_1120# w_n6894_n2773# sky130_fd_pr__pfet_01v8 ad=0.1421 pd=1.56 as=0.1421 ps=1.56 w=0.49 l=0.2
X407 a_974_1120# a_921_1249# a_876_1120# w_n6894_n2773# sky130_fd_pr__pfet_01v8 ad=0.1421 pd=1.56 as=0.1421 ps=1.56 w=0.49 l=0.2
X408 a_n6234_n884# a_n6287_n755# a_n6332_n884# w_n6894_n2773# sky130_fd_pr__pfet_01v8 ad=0.1421 pd=1.56 as=0.1421 ps=1.56 w=0.49 l=0.2
X409 a_n2418_n1886# a_n2471_n1983# a_n2516_n1886# w_n6894_n2773# sky130_fd_pr__pfet_01v8 ad=0.1421 pd=1.56 as=0.1421 ps=1.56 w=0.49 l=0.2
X410 a_6486_1454# a_6433_1357# a_6388_1454# w_n6894_n2773# sky130_fd_pr__pfet_01v8 ad=0.1421 pd=1.56 as=0.1421 ps=1.56 w=0.49 l=0.2
X411 a_3306_n550# a_3253_n421# a_3208_n550# w_n6894_n2773# sky130_fd_pr__pfet_01v8 ad=0.1421 pd=1.56 as=0.1421 ps=1.56 w=0.49 l=0.2
X412 a_1186_n2220# a_1133_n2317# a_1088_n2220# w_n6894_n2773# sky130_fd_pr__pfet_01v8 ad=0.1421 pd=1.56 as=0.1421 ps=1.56 w=0.49 l=0.2
X413 a_2458_n1552# a_2405_n1649# a_2360_n1552# w_n6894_n2773# sky130_fd_pr__pfet_01v8 ad=0.1421 pd=1.56 as=0.1421 ps=1.56 w=0.49 l=0.2
X414 a_126_n884# a_73_n755# a_28_n884# w_n6894_n2773# sky130_fd_pr__pfet_01v8 ad=0.1421 pd=1.56 as=0.1421 ps=1.56 w=0.49 l=0.2
X415 a_n1782_n884# a_n1835_n981# a_n1880_n884# w_n6894_n2773# sky130_fd_pr__pfet_01v8 ad=0.1421 pd=1.56 as=0.1421 ps=1.56 w=0.49 l=0.2
X416 a_338_n2554# a_285_n2425# a_240_n2554# w_n6894_n2773# sky130_fd_pr__pfet_01v8 ad=0.1421 pd=1.56 as=0.1421 ps=1.56 w=0.49 l=0.2
X417 a_n3690_2456# a_n3743_2585# a_n3788_2456# w_n6894_n2773# sky130_fd_pr__pfet_01v8 ad=0.1421 pd=1.56 as=0.1421 ps=1.56 w=0.49 l=0.2
X418 a_3942_786# a_3889_689# a_3844_786# w_n6894_n2773# sky130_fd_pr__pfet_01v8 ad=0.1421 pd=1.56 as=0.1421 ps=1.56 w=0.49 l=0.2
X419 a_n3266_n2554# a_n3319_n2651# a_n3364_n2554# w_n6894_n2773# sky130_fd_pr__pfet_01v8 ad=0.1421 pd=1.56 as=0.1421 ps=1.56 w=0.49 l=0.2
X420 a_2034_n1218# a_1981_n1089# a_1936_n1218# w_n6894_n2773# sky130_fd_pr__pfet_01v8 ad=0.1421 pd=1.56 as=0.1421 ps=1.56 w=0.49 l=0.2
X421 a_n4114_2456# a_n4167_2585# a_n4212_2456# w_n6894_n2773# sky130_fd_pr__pfet_01v8 ad=0.1421 pd=1.56 as=0.1421 ps=1.56 w=0.49 l=0.2
X422 a_n1782_786# a_n1835_915# a_n1880_786# w_n6894_n2773# sky130_fd_pr__pfet_01v8 ad=0.1421 pd=1.56 as=0.1421 ps=1.56 w=0.49 l=0.2
X423 a_n3690_n884# a_n3743_n755# a_n3788_n884# w_n6894_n2773# sky130_fd_pr__pfet_01v8 ad=0.1421 pd=1.56 as=0.1421 ps=1.56 w=0.49 l=0.2
X424 a_n2630_1788# a_n2683_1691# a_n2728_1788# w_n6894_n2773# sky130_fd_pr__pfet_01v8 ad=0.1421 pd=1.56 as=0.1421 ps=1.56 w=0.49 l=0.2
X425 a_4790_n216# a_4737_n87# a_4692_n216# w_n6894_n2773# sky130_fd_pr__pfet_01v8 ad=0.1421 pd=1.56 as=0.1421 ps=1.56 w=0.49 l=0.2
X426 a_n298_n1552# a_n351_n1423# a_n396_n1552# w_n6894_n2773# sky130_fd_pr__pfet_01v8 ad=0.1421 pd=1.56 as=0.1421 ps=1.56 w=0.49 l=0.2
X427 a_6062_n1218# a_6009_n1315# a_5964_n1218# w_n6894_n2773# sky130_fd_pr__pfet_01v8 ad=0.1421 pd=1.56 as=0.1421 ps=1.56 w=0.49 l=0.2
X428 a_1398_2122# a_1345_2025# a_1300_2122# w_n6894_n2773# sky130_fd_pr__pfet_01v8 ad=0.1421 pd=1.56 as=0.1421 ps=1.56 w=0.49 l=0.2
X429 a_n3054_1788# a_n3107_1691# a_n3152_1788# w_n6894_n2773# sky130_fd_pr__pfet_01v8 ad=0.1421 pd=1.56 as=0.1421 ps=1.56 w=0.49 l=0.2
X430 a_974_1788# a_921_1917# a_876_1788# w_n6894_n2773# sky130_fd_pr__pfet_01v8 ad=0.1421 pd=1.56 as=0.1421 ps=1.56 w=0.49 l=0.2
X431 a_n4962_1120# a_n5015_1249# a_n5060_1120# w_n6894_n2773# sky130_fd_pr__pfet_01v8 ad=0.1421 pd=1.56 as=0.1421 ps=1.56 w=0.49 l=0.2
X432 a_2882_452# a_2829_355# a_2784_452# w_n6894_n2773# sky130_fd_pr__pfet_01v8 ad=0.1421 pd=1.56 as=0.1421 ps=1.56 w=0.49 l=0.2
X433 a_n4114_n884# a_n4167_n755# a_n4212_n884# w_n6894_n2773# sky130_fd_pr__pfet_01v8 ad=0.1421 pd=1.56 as=0.1421 ps=1.56 w=0.49 l=0.2
X434 a_974_n2554# a_921_n2651# a_876_n2554# w_n6894_n2773# sky130_fd_pr__pfet_01v8 ad=0.1421 pd=1.56 as=0.1421 ps=1.56 w=0.49 l=0.2
X435 a_4578_n2554# a_4525_n2425# a_4480_n2554# w_n6894_n2773# sky130_fd_pr__pfet_01v8 ad=0.1421 pd=1.56 as=0.1421 ps=1.56 w=0.49 l=0.2
X436 a_n2842_n2220# a_n2895_n2091# a_n2940_n2220# w_n6894_n2773# sky130_fd_pr__pfet_01v8 ad=0.1421 pd=1.56 as=0.1421 ps=1.56 w=0.49 l=0.2
X437 a_n2206_n1886# a_n2259_n1757# a_n2304_n1886# w_n6894_n2773# sky130_fd_pr__pfet_01v8 ad=0.1421 pd=1.56 as=0.1421 ps=1.56 w=0.49 l=0.2
X438 a_4366_1454# a_4313_1357# a_4268_1454# w_n6894_n2773# sky130_fd_pr__pfet_01v8 ad=0.1421 pd=1.56 as=0.1421 ps=1.56 w=0.49 l=0.2
X439 a_1186_n550# a_1133_n421# a_1088_n550# w_n6894_n2773# sky130_fd_pr__pfet_01v8 ad=0.1421 pd=1.56 as=0.1421 ps=1.56 w=0.49 l=0.2
X440 a_2246_n1552# a_2193_n1423# a_2148_n1552# w_n6894_n2773# sky130_fd_pr__pfet_01v8 ad=0.1421 pd=1.56 as=0.1421 ps=1.56 w=0.49 l=0.2
X441 a_2670_786# a_2617_689# a_2572_786# w_n6894_n2773# sky130_fd_pr__pfet_01v8 ad=0.1421 pd=1.56 as=0.1421 ps=1.56 w=0.49 l=0.2
X442 a_6698_n216# a_6645_n313# a_6600_n216# w_n6894_n2773# sky130_fd_pr__pfet_01v8 ad=0.1421 pd=1.56 as=0.1421 ps=1.56 w=0.49 l=0.2
X443 a_n4750_n1218# a_n4803_n1089# a_n4848_n1218# w_n6894_n2773# sky130_fd_pr__pfet_01v8 ad=0.1421 pd=1.56 as=0.1421 ps=1.56 w=0.49 l=0.2
X444 a_n1570_2456# a_n1623_2585# a_n1668_2456# w_n6894_n2773# sky130_fd_pr__pfet_01v8 ad=0.1421 pd=1.56 as=0.1421 ps=1.56 w=0.49 l=0.2
X445 a_n722_118# a_n775_21# a_n820_118# w_n6894_n2773# sky130_fd_pr__pfet_01v8 ad=0.1421 pd=1.56 as=0.1421 ps=1.56 w=0.49 l=0.2
X446 a_3518_n1886# a_3465_n1983# a_3420_n1886# w_n6894_n2773# sky130_fd_pr__pfet_01v8 ad=0.1421 pd=1.56 as=0.1421 ps=1.56 w=0.49 l=0.2
X447 a_338_2456# a_285_2359# a_240_2456# w_n6894_n2773# sky130_fd_pr__pfet_01v8 ad=0.1421 pd=1.56 as=0.1421 ps=1.56 w=0.49 l=0.2
X448 a_5002_2456# a_4949_2359# a_4904_2456# w_n6894_n2773# sky130_fd_pr__pfet_01v8 ad=0.1421 pd=1.56 as=0.1421 ps=1.56 w=0.49 l=0.2
X449 a_1610_452# a_1557_355# a_1512_452# w_n6894_n2773# sky130_fd_pr__pfet_01v8 ad=0.1421 pd=1.56 as=0.1421 ps=1.56 w=0.49 l=0.2
X450 a_1822_n1218# a_1769_n1315# a_1724_n1218# w_n6894_n2773# sky130_fd_pr__pfet_01v8 ad=0.1421 pd=1.56 as=0.1421 ps=1.56 w=0.49 l=0.2
X451 a_n1994_2456# a_n2047_2585# a_n2092_2456# w_n6894_n2773# sky130_fd_pr__pfet_01v8 ad=0.1421 pd=1.56 as=0.1421 ps=1.56 w=0.49 l=0.2
X452 a_n1570_n884# a_n1623_n755# a_n1668_n884# w_n6894_n2773# sky130_fd_pr__pfet_01v8 ad=0.1421 pd=1.56 as=0.1421 ps=1.56 w=0.49 l=0.2
X453 a_n1570_452# a_n1623_581# a_n1668_452# w_n6894_n2773# sky130_fd_pr__pfet_01v8 ad=0.1421 pd=1.56 as=0.1421 ps=1.56 w=0.49 l=0.2
X454 a_2670_n216# a_2617_n87# a_2572_n216# w_n6894_n2773# sky130_fd_pr__pfet_01v8 ad=0.1421 pd=1.56 as=0.1421 ps=1.56 w=0.49 l=0.2
X455 a_338_n884# a_285_n981# a_240_n884# w_n6894_n2773# sky130_fd_pr__pfet_01v8 ad=0.1421 pd=1.56 as=0.1421 ps=1.56 w=0.49 l=0.2
X456 a_1822_1120# a_1769_1249# a_1724_1120# w_n6894_n2773# sky130_fd_pr__pfet_01v8 ad=0.1421 pd=1.56 as=0.1421 ps=1.56 w=0.49 l=0.2
X457 a_5850_1120# a_5797_1023# a_5752_1120# w_n6894_n2773# sky130_fd_pr__pfet_01v8 ad=0.1421 pd=1.56 as=0.1421 ps=1.56 w=0.49 l=0.2
X458 a_2034_452# a_1981_355# a_1936_452# w_n6894_n2773# sky130_fd_pr__pfet_01v8 ad=0.1421 pd=1.56 as=0.1421 ps=1.56 w=0.49 l=0.2
X459 a_n86_n1552# a_n139_n1649# a_n184_n1552# w_n6894_n2773# sky130_fd_pr__pfet_01v8 ad=0.1421 pd=1.56 as=0.1421 ps=1.56 w=0.49 l=0.2
X460 a_5002_n884# a_4949_n981# a_4904_n884# w_n6894_n2773# sky130_fd_pr__pfet_01v8 ad=0.1421 pd=1.56 as=0.1421 ps=1.56 w=0.49 l=0.2
X461 a_n4962_1788# a_n5015_1917# a_n5060_1788# w_n6894_n2773# sky130_fd_pr__pfet_01v8 ad=0.1421 pd=1.56 as=0.1421 ps=1.56 w=0.49 l=0.2
X462 a_n1994_n884# a_n2047_n755# a_n2092_n884# w_n6894_n2773# sky130_fd_pr__pfet_01v8 ad=0.1421 pd=1.56 as=0.1421 ps=1.56 w=0.49 l=0.2
X463 a_762_n2554# a_709_n2425# a_664_n2554# w_n6894_n2773# sky130_fd_pr__pfet_01v8 ad=0.1421 pd=1.56 as=0.1421 ps=1.56 w=0.49 l=0.2
X464 a_4366_n2554# a_4313_n2651# a_4268_n2554# w_n6894_n2773# sky130_fd_pr__pfet_01v8 ad=0.1421 pd=1.56 as=0.1421 ps=1.56 w=0.49 l=0.2
X465 a_n1994_n1886# a_n2047_n1983# a_n2092_n1886# w_n6894_n2773# sky130_fd_pr__pfet_01v8 ad=0.1421 pd=1.56 as=0.1421 ps=1.56 w=0.49 l=0.2
X466 a_n86_2456# a_n139_2359# a_n184_2456# w_n6894_n2773# sky130_fd_pr__pfet_01v8 ad=0.1421 pd=1.56 as=0.1421 ps=1.56 w=0.49 l=0.2
X467 a_2246_1454# a_2193_1357# a_2148_1454# w_n6894_n2773# sky130_fd_pr__pfet_01v8 ad=0.1421 pd=1.56 as=0.1421 ps=1.56 w=0.49 l=0.2
X468 a_n3902_n1552# a_n3955_n1649# a_n4000_n1552# w_n6894_n2773# sky130_fd_pr__pfet_01v8 ad=0.1421 pd=1.56 as=0.1421 ps=1.56 w=0.49 l=0.2
X469 a_n6446_1454# a_n6499_1583# a_n6544_1454# w_n6894_n2773# sky130_fd_pr__pfet_01v8 ad=0.1421 pd=1.56 as=0.1421 ps=1.56 w=0.49 l=0.2
X470 a_1822_786# a_1769_689# a_1724_786# w_n6894_n2773# sky130_fd_pr__pfet_01v8 ad=0.1421 pd=1.56 as=0.1421 ps=1.56 w=0.49 l=0.2
X471 a_n86_n884# a_n139_n981# a_n184_n884# w_n6894_n2773# sky130_fd_pr__pfet_01v8 ad=0.1421 pd=1.56 as=0.1421 ps=1.56 w=0.49 l=0.2
X472 a_4578_n216# a_4525_n313# a_4480_n216# w_n6894_n2773# sky130_fd_pr__pfet_01v8 ad=0.1421 pd=1.56 as=0.1421 ps=1.56 w=0.49 l=0.2
X473 a_n3054_n1552# a_n3107_n1649# a_n3152_n1552# w_n6894_n2773# sky130_fd_pr__pfet_01v8 ad=0.1421 pd=1.56 as=0.1421 ps=1.56 w=0.49 l=0.2
X474 a_2458_452# a_2405_355# a_2360_452# w_n6894_n2773# sky130_fd_pr__pfet_01v8 ad=0.1421 pd=1.56 as=0.1421 ps=1.56 w=0.49 l=0.2
X475 a_3306_n1886# a_3253_n1757# a_3208_n1886# w_n6894_n2773# sky130_fd_pr__pfet_01v8 ad=0.1421 pd=1.56 as=0.1421 ps=1.56 w=0.49 l=0.2
X476 a_n4538_n1218# a_n4591_n1315# a_n4636_n1218# w_n6894_n2773# sky130_fd_pr__pfet_01v8 ad=0.1421 pd=1.56 as=0.1421 ps=1.56 w=0.49 l=0.2
X477 a_2882_2456# a_2829_2359# a_2784_2456# w_n6894_n2773# sky130_fd_pr__pfet_01v8 ad=0.1421 pd=1.56 as=0.1421 ps=1.56 w=0.49 l=0.2
X478 a_1610_n1218# a_1557_n1089# a_1512_n1218# w_n6894_n2773# sky130_fd_pr__pfet_01v8 ad=0.1421 pd=1.56 as=0.1421 ps=1.56 w=0.49 l=0.2
X479 a_1822_1788# a_1769_1917# a_1724_1788# w_n6894_n2773# sky130_fd_pr__pfet_01v8 ad=0.1421 pd=1.56 as=0.1421 ps=1.56 w=0.49 l=0.2
X480 a_5850_1788# a_5797_1691# a_5752_1788# w_n6894_n2773# sky130_fd_pr__pfet_01v8 ad=0.1421 pd=1.56 as=0.1421 ps=1.56 w=0.49 l=0.2
X481 a_2246_786# a_2193_689# a_2148_786# w_n6894_n2773# sky130_fd_pr__pfet_01v8 ad=0.1421 pd=1.56 as=0.1421 ps=1.56 w=0.49 l=0.2
X482 a_2882_n884# a_2829_n981# a_2784_n884# w_n6894_n2773# sky130_fd_pr__pfet_01v8 ad=0.1421 pd=1.56 as=0.1421 ps=1.56 w=0.49 l=0.2
X483 a_n5386_2122# a_n5439_2025# a_n5484_2122# w_n6894_n2773# sky130_fd_pr__pfet_01v8 ad=0.1421 pd=1.56 as=0.1421 ps=1.56 w=0.49 l=0.2
X484 a_n1358_2122# a_n1411_2251# a_n1456_2122# w_n6894_n2773# sky130_fd_pr__pfet_01v8 ad=0.1421 pd=1.56 as=0.1421 ps=1.56 w=0.49 l=0.2
X485 a_n298_118# a_n351_21# a_n396_118# w_n6894_n2773# sky130_fd_pr__pfet_01v8 ad=0.1421 pd=1.56 as=0.1421 ps=1.56 w=0.49 l=0.2
X486 a_550_n2554# a_497_n2651# a_452_n2554# w_n6894_n2773# sky130_fd_pr__pfet_01v8 ad=0.1421 pd=1.56 as=0.1421 ps=1.56 w=0.49 l=0.2
X487 a_4154_n2554# a_4101_n2425# a_4056_n2554# w_n6894_n2773# sky130_fd_pr__pfet_01v8 ad=0.1421 pd=1.56 as=0.1421 ps=1.56 w=0.49 l=0.2
X488 a_1186_452# a_1133_355# a_1088_452# w_n6894_n2773# sky130_fd_pr__pfet_01v8 ad=0.1421 pd=1.56 as=0.1421 ps=1.56 w=0.49 l=0.2
X489 a_n5174_n550# a_n5227_n421# a_n5272_n550# w_n6894_n2773# sky130_fd_pr__pfet_01v8 ad=0.1421 pd=1.56 as=0.1421 ps=1.56 w=0.49 l=0.2
X490 a_n1146_n550# a_n1199_n647# a_n1244_n550# w_n6894_n2773# sky130_fd_pr__pfet_01v8 ad=0.1421 pd=1.56 as=0.1421 ps=1.56 w=0.49 l=0.2
X491 a_n4326_1454# a_n4379_1583# a_n4424_1454# w_n6894_n2773# sky130_fd_pr__pfet_01v8 ad=0.1421 pd=1.56 as=0.1421 ps=1.56 w=0.49 l=0.2
X492 a_3942_n1886# a_3889_n1983# a_3844_n1886# w_n6894_n2773# sky130_fd_pr__pfet_01v8 ad=0.1421 pd=1.56 as=0.1421 ps=1.56 w=0.49 l=0.2
X493 a_2458_n216# a_2405_n313# a_2360_n216# w_n6894_n2773# sky130_fd_pr__pfet_01v8 ad=0.1421 pd=1.56 as=0.1421 ps=1.56 w=0.49 l=0.2
X494 a_n6658_n2220# a_n6711_n2091# a_n6756_n2220# w_n6894_n2773# sky130_fd_pr__pfet_01v8 ad=0.1421 pd=1.56 as=0.1421 ps=1.56 w=0.49 l=0.2
X495 a_5214_2456# a_5161_2585# a_5116_2456# w_n6894_n2773# sky130_fd_pr__pfet_01v8 ad=0.1421 pd=1.56 as=0.1421 ps=1.56 w=0.49 l=0.2
X496 a_3094_n1886# a_3041_n1983# a_2996_n1886# w_n6894_n2773# sky130_fd_pr__pfet_01v8 ad=0.1421 pd=1.56 as=0.1421 ps=1.56 w=0.49 l=0.2
X497 a_n4326_n1218# a_n4379_n1089# a_n4424_n1218# w_n6894_n2773# sky130_fd_pr__pfet_01v8 ad=0.1421 pd=1.56 as=0.1421 ps=1.56 w=0.49 l=0.2
X498 a_n6658_n216# a_n6711_n87# a_n6756_n216# w_n6894_n2773# sky130_fd_pr__pfet_01v8 ad=0.1421 pd=1.56 as=0.1421 ps=1.56 w=0.49 l=0.2
X499 a_3730_n2220# a_3677_n2317# a_3632_n2220# w_n6894_n2773# sky130_fd_pr__pfet_01v8 ad=0.1421 pd=1.56 as=0.1421 ps=1.56 w=0.49 l=0.2
X500 a_6062_1120# a_6009_1249# a_5964_1120# w_n6894_n2773# sky130_fd_pr__pfet_01v8 ad=0.1421 pd=1.56 as=0.1421 ps=1.56 w=0.49 l=0.2
X501 a_5002_n1552# a_4949_n1649# a_4904_n1552# w_n6894_n2773# sky130_fd_pr__pfet_01v8 ad=0.1421 pd=1.56 as=0.1421 ps=1.56 w=0.49 l=0.2
X502 a_5214_n884# a_5161_n755# a_5116_n884# w_n6894_n2773# sky130_fd_pr__pfet_01v8 ad=0.1421 pd=1.56 as=0.1421 ps=1.56 w=0.49 l=0.2
X503 a_1398_786# a_1345_689# a_1300_786# w_n6894_n2773# sky130_fd_pr__pfet_01v8 ad=0.1421 pd=1.56 as=0.1421 ps=1.56 w=0.49 l=0.2
X504 a_5638_n1218# a_5585_n1315# a_5540_n1218# w_n6894_n2773# sky130_fd_pr__pfet_01v8 ad=0.1421 pd=1.56 as=0.1421 ps=1.56 w=0.49 l=0.2
X505 a_n3266_2122# a_n3319_2025# a_n3364_2122# w_n6894_n2773# sky130_fd_pr__pfet_01v8 ad=0.1421 pd=1.56 as=0.1421 ps=1.56 w=0.49 l=0.2
X506 a_2034_n550# a_1981_n421# a_1936_n550# w_n6894_n2773# sky130_fd_pr__pfet_01v8 ad=0.1421 pd=1.56 as=0.1421 ps=1.56 w=0.49 l=0.2
X507 a_n2206_1454# a_n2259_1583# a_n2304_1454# w_n6894_n2773# sky130_fd_pr__pfet_01v8 ad=0.1421 pd=1.56 as=0.1421 ps=1.56 w=0.49 l=0.2
X508 a_n722_n216# a_n775_n87# a_n820_n216# w_n6894_n2773# sky130_fd_pr__pfet_01v8 ad=0.1421 pd=1.56 as=0.1421 ps=1.56 w=0.49 l=0.2
X509 a_n6446_n2220# a_n6499_n2317# a_n6544_n2220# w_n6894_n2773# sky130_fd_pr__pfet_01v8 ad=0.1421 pd=1.56 as=0.1421 ps=1.56 w=0.49 l=0.2
X510 a_3094_2456# a_3041_2585# a_2996_2456# w_n6894_n2773# sky130_fd_pr__pfet_01v8 ad=0.1421 pd=1.56 as=0.1421 ps=1.56 w=0.49 l=0.2
X511 a_550_1454# a_497_1357# a_452_1454# w_n6894_n2773# sky130_fd_pr__pfet_01v8 ad=0.1421 pd=1.56 as=0.1421 ps=1.56 w=0.49 l=0.2
X512 a_n4114_n1218# a_n4167_n1315# a_n4212_n1218# w_n6894_n2773# sky130_fd_pr__pfet_01v8 ad=0.1421 pd=1.56 as=0.1421 ps=1.56 w=0.49 l=0.2
X513 a_n4538_n216# a_n4591_n87# a_n4636_n216# w_n6894_n2773# sky130_fd_pr__pfet_01v8 ad=0.1421 pd=1.56 as=0.1421 ps=1.56 w=0.49 l=0.2
X514 a_6062_1788# a_6009_1917# a_5964_1788# w_n6894_n2773# sky130_fd_pr__pfet_01v8 ad=0.1421 pd=1.56 as=0.1421 ps=1.56 w=0.49 l=0.2
X515 a_n298_1454# a_n351_1357# a_n396_1454# w_n6894_n2773# sky130_fd_pr__pfet_01v8 ad=0.1421 pd=1.56 as=0.1421 ps=1.56 w=0.49 l=0.2
X516 a_n2630_n2554# a_n2683_n2425# a_n2728_n2554# w_n6894_n2773# sky130_fd_pr__pfet_01v8 ad=0.1421 pd=1.56 as=0.1421 ps=1.56 w=0.49 l=0.2
X517 a_4790_n1552# a_4737_n1423# a_4692_n1552# w_n6894_n2773# sky130_fd_pr__pfet_01v8 ad=0.1421 pd=1.56 as=0.1421 ps=1.56 w=0.49 l=0.2
X518 a_3094_n884# a_3041_n755# a_2996_n884# w_n6894_n2773# sky130_fd_pr__pfet_01v8 ad=0.1421 pd=1.56 as=0.1421 ps=1.56 w=0.49 l=0.2
X519 a_n2842_2456# a_n2895_2585# a_n2940_2456# w_n6894_n2773# sky130_fd_pr__pfet_01v8 ad=0.1421 pd=1.56 as=0.1421 ps=1.56 w=0.49 l=0.2
X520 a_5426_n1218# a_5373_n1089# a_5328_n1218# w_n6894_n2773# sky130_fd_pr__pfet_01v8 ad=0.1421 pd=1.56 as=0.1421 ps=1.56 w=0.49 l=0.2
X521 a_n2842_n884# a_n2895_n755# a_n2940_n884# w_n6894_n2773# sky130_fd_pr__pfet_01v8 ad=0.1421 pd=1.56 as=0.1421 ps=1.56 w=0.49 l=0.2
X522 a_n934_2456# a_n987_2359# a_n1032_2456# w_n6894_n2773# sky130_fd_pr__pfet_01v8 ad=0.1421 pd=1.56 as=0.1421 ps=1.56 w=0.49 l=0.2
X523 a_3942_n550# a_3889_n647# a_3844_n550# w_n6894_n2773# sky130_fd_pr__pfet_01v8 ad=0.1421 pd=1.56 as=0.1421 ps=1.56 w=0.49 l=0.2
X524 a_n4750_2456# a_n4803_2359# a_n4848_2456# w_n6894_n2773# sky130_fd_pr__pfet_01v8 ad=0.1421 pd=1.56 as=0.1421 ps=1.56 w=0.49 l=0.2
X525 a_n6234_n2220# a_n6287_n2091# a_n6332_n2220# w_n6894_n2773# sky130_fd_pr__pfet_01v8 ad=0.1421 pd=1.56 as=0.1421 ps=1.56 w=0.49 l=0.2
X526 a_n934_n884# a_n987_n981# a_n1032_n884# w_n6894_n2773# sky130_fd_pr__pfet_01v8 ad=0.1421 pd=1.56 as=0.1421 ps=1.56 w=0.49 l=0.2
X527 a_126_786# a_73_689# a_28_786# w_n6894_n2773# sky130_fd_pr__pfet_01v8 ad=0.1421 pd=1.56 as=0.1421 ps=1.56 w=0.49 l=0.2
X528 a_n2418_n216# a_n2471_n87# a_n2516_n216# w_n6894_n2773# sky130_fd_pr__pfet_01v8 ad=0.1421 pd=1.56 as=0.1421 ps=1.56 w=0.49 l=0.2
X529 a_n5598_1120# a_n5651_1023# a_n5696_1120# w_n6894_n2773# sky130_fd_pr__pfet_01v8 ad=0.1421 pd=1.56 as=0.1421 ps=1.56 w=0.49 l=0.2
X530 a_n5174_118# a_n5227_247# a_n5272_118# w_n6894_n2773# sky130_fd_pr__pfet_01v8 ad=0.1421 pd=1.56 as=0.1421 ps=1.56 w=0.49 l=0.2
X531 a_n2418_n2554# a_n2471_n2651# a_n2516_n2554# w_n6894_n2773# sky130_fd_pr__pfet_01v8 ad=0.1421 pd=1.56 as=0.1421 ps=1.56 w=0.49 l=0.2
X532 a_n4750_n884# a_n4803_n981# a_n4848_n884# w_n6894_n2773# sky130_fd_pr__pfet_01v8 ad=0.1421 pd=1.56 as=0.1421 ps=1.56 w=0.49 l=0.2
X533 a_762_n216# a_709_n313# a_664_n216# w_n6894_n2773# sky130_fd_pr__pfet_01v8 ad=0.1421 pd=1.56 as=0.1421 ps=1.56 w=0.49 l=0.2
X534 a_6486_2122# a_6433_2025# a_6388_2122# w_n6894_n2773# sky130_fd_pr__pfet_01v8 ad=0.1421 pd=1.56 as=0.1421 ps=1.56 w=0.49 l=0.2
X535 a_n6022_1120# a_n6075_1023# a_n6120_1120# w_n6894_n2773# sky130_fd_pr__pfet_01v8 ad=0.1421 pd=1.56 as=0.1421 ps=1.56 w=0.49 l=0.2
X536 a_n5598_118# a_n5651_247# a_n5696_118# w_n6894_n2773# sky130_fd_pr__pfet_01v8 ad=0.1421 pd=1.56 as=0.1421 ps=1.56 w=0.49 l=0.2
X537 a_n1570_n1218# a_n1623_n1315# a_n1668_n1218# w_n6894_n2773# sky130_fd_pr__pfet_01v8 ad=0.1421 pd=1.56 as=0.1421 ps=1.56 w=0.49 l=0.2
X538 a_n510_n216# a_n563_n313# a_n608_n216# w_n6894_n2773# sky130_fd_pr__pfet_01v8 ad=0.1421 pd=1.56 as=0.1421 ps=1.56 w=0.49 l=0.2
X539 a_5214_n1218# a_5161_n1315# a_5116_n1218# w_n6894_n2773# sky130_fd_pr__pfet_01v8 ad=0.1421 pd=1.56 as=0.1421 ps=1.56 w=0.49 l=0.2
X540 a_6274_n550# a_6221_n421# a_6176_n550# w_n6894_n2773# sky130_fd_pr__pfet_01v8 ad=0.1421 pd=1.56 as=0.1421 ps=1.56 w=0.49 l=0.2
X541 a_5426_1454# a_5373_1583# a_5328_1454# w_n6894_n2773# sky130_fd_pr__pfet_01v8 ad=0.1421 pd=1.56 as=0.1421 ps=1.56 w=0.49 l=0.2
X542 a_n1358_n1886# a_n1411_n1757# a_n1456_n1886# w_n6894_n2773# sky130_fd_pr__pfet_01v8 ad=0.1421 pd=1.56 as=0.1421 ps=1.56 w=0.49 l=0.2
X543 a_6062_118# a_6009_21# a_5964_118# w_n6894_n2773# sky130_fd_pr__pfet_01v8 ad=0.1421 pd=1.56 as=0.1421 ps=1.56 w=0.49 l=0.2
X544 a_1398_n1552# a_1345_n1423# a_1300_n1552# w_n6894_n2773# sky130_fd_pr__pfet_01v8 ad=0.1421 pd=1.56 as=0.1421 ps=1.56 w=0.49 l=0.2
X545 a_n2630_2456# a_n2683_2359# a_n2728_2456# w_n6894_n2773# sky130_fd_pr__pfet_01v8 ad=0.1421 pd=1.56 as=0.1421 ps=1.56 w=0.49 l=0.2
X546 a_n6022_n2220# a_n6075_n2317# a_n6120_n2220# w_n6894_n2773# sky130_fd_pr__pfet_01v8 ad=0.1421 pd=1.56 as=0.1421 ps=1.56 w=0.49 l=0.2
X547 a_6486_118# a_6433_21# a_6388_118# w_n6894_n2773# sky130_fd_pr__pfet_01v8 ad=0.1421 pd=1.56 as=0.1421 ps=1.56 w=0.49 l=0.2
X548 a_n3478_1120# a_n3531_1023# a_n3576_1120# w_n6894_n2773# sky130_fd_pr__pfet_01v8 ad=0.1421 pd=1.56 as=0.1421 ps=1.56 w=0.49 l=0.2
X549 a_n4326_118# a_n4379_247# a_n4424_118# w_n6894_n2773# sky130_fd_pr__pfet_01v8 ad=0.1421 pd=1.56 as=0.1421 ps=1.56 w=0.49 l=0.2
X550 a_n3054_2456# a_n3107_2359# a_n3152_2456# w_n6894_n2773# sky130_fd_pr__pfet_01v8 ad=0.1421 pd=1.56 as=0.1421 ps=1.56 w=0.49 l=0.2
X551 a_974_2456# a_921_2585# a_876_2456# w_n6894_n2773# sky130_fd_pr__pfet_01v8 ad=0.1421 pd=1.56 as=0.1421 ps=1.56 w=0.49 l=0.2
X552 a_n5598_1788# a_n5651_1691# a_n5696_1788# w_n6894_n2773# sky130_fd_pr__pfet_01v8 ad=0.1421 pd=1.56 as=0.1421 ps=1.56 w=0.49 l=0.2
X553 a_3730_n216# a_3677_n313# a_3632_n216# w_n6894_n2773# sky130_fd_pr__pfet_01v8 ad=0.1421 pd=1.56 as=0.1421 ps=1.56 w=0.49 l=0.2
X554 a_n2206_n2554# a_n2259_n2425# a_n2304_n2554# w_n6894_n2773# sky130_fd_pr__pfet_01v8 ad=0.1421 pd=1.56 as=0.1421 ps=1.56 w=0.49 l=0.2
X555 a_n2630_n884# a_n2683_n981# a_n2728_n884# w_n6894_n2773# sky130_fd_pr__pfet_01v8 ad=0.1421 pd=1.56 as=0.1421 ps=1.56 w=0.49 l=0.2
X556 a_n4750_118# a_n4803_247# a_n4848_118# w_n6894_n2773# sky130_fd_pr__pfet_01v8 ad=0.1421 pd=1.56 as=0.1421 ps=1.56 w=0.49 l=0.2
X557 a_n3690_n2220# a_n3743_n2091# a_n3788_n2220# w_n6894_n2773# sky130_fd_pr__pfet_01v8 ad=0.1421 pd=1.56 as=0.1421 ps=1.56 w=0.49 l=0.2
X558 a_5850_n1218# a_5797_n1089# a_5752_n1218# w_n6894_n2773# sky130_fd_pr__pfet_01v8 ad=0.1421 pd=1.56 as=0.1421 ps=1.56 w=0.49 l=0.2
X559 a_4366_2122# a_4313_2025# a_4268_2122# w_n6894_n2773# sky130_fd_pr__pfet_01v8 ad=0.1421 pd=1.56 as=0.1421 ps=1.56 w=0.49 l=0.2
X560 a_n6022_1788# a_n6075_1691# a_n6120_1788# w_n6894_n2773# sky130_fd_pr__pfet_01v8 ad=0.1421 pd=1.56 as=0.1421 ps=1.56 w=0.49 l=0.2
X561 a_974_n884# a_921_n755# a_876_n884# w_n6894_n2773# sky130_fd_pr__pfet_01v8 ad=0.1421 pd=1.56 as=0.1421 ps=1.56 w=0.49 l=0.2
X562 a_n3054_n884# a_n3107_n981# a_n3152_n884# w_n6894_n2773# sky130_fd_pr__pfet_01v8 ad=0.1421 pd=1.56 as=0.1421 ps=1.56 w=0.49 l=0.2
X563 a_3306_1454# a_3253_1583# a_3208_1454# w_n6894_n2773# sky130_fd_pr__pfet_01v8 ad=0.1421 pd=1.56 as=0.1421 ps=1.56 w=0.49 l=0.2
X564 a_n6234_452# a_n6287_581# a_n6332_452# w_n6894_n2773# sky130_fd_pr__pfet_01v8 ad=0.1421 pd=1.56 as=0.1421 ps=1.56 w=0.49 l=0.2
X565 a_4154_n550# a_4101_n421# a_4056_n550# w_n6894_n2773# sky130_fd_pr__pfet_01v8 ad=0.1421 pd=1.56 as=0.1421 ps=1.56 w=0.49 l=0.2
X566 a_n1146_n1886# a_n1199_n1983# a_n1244_n1886# w_n6894_n2773# sky130_fd_pr__pfet_01v8 ad=0.1421 pd=1.56 as=0.1421 ps=1.56 w=0.49 l=0.2
X567 a_5214_118# a_5161_21# a_5116_118# w_n6894_n2773# sky130_fd_pr__pfet_01v8 ad=0.1421 pd=1.56 as=0.1421 ps=1.56 w=0.49 l=0.2
X568 a_3518_n2554# a_3465_n2651# a_3420_n2554# w_n6894_n2773# sky130_fd_pr__pfet_01v8 ad=0.1421 pd=1.56 as=0.1421 ps=1.56 w=0.49 l=0.2
X569 a_n6658_452# a_n6711_581# a_n6756_452# w_n6894_n2773# sky130_fd_pr__pfet_01v8 ad=0.1421 pd=1.56 as=0.1421 ps=1.56 w=0.49 l=0.2
X570 a_n3054_118# a_n3107_247# a_n3152_118# w_n6894_n2773# sky130_fd_pr__pfet_01v8 ad=0.1421 pd=1.56 as=0.1421 ps=1.56 w=0.49 l=0.2
X571 a_1186_n1552# a_1133_n1649# a_1088_n1552# w_n6894_n2773# sky130_fd_pr__pfet_01v8 ad=0.1421 pd=1.56 as=0.1421 ps=1.56 w=0.49 l=0.2
X572 a_5638_n216# a_5585_n87# a_5540_n216# w_n6894_n2773# sky130_fd_pr__pfet_01v8 ad=0.1421 pd=1.56 as=0.1421 ps=1.56 w=0.49 l=0.2
X573 a_n3902_n550# a_n3955_n421# a_n4000_n550# w_n6894_n2773# sky130_fd_pr__pfet_01v8 ad=0.1421 pd=1.56 as=0.1421 ps=1.56 w=0.49 l=0.2
X574 a_n6022_786# a_n6075_915# a_n6120_786# w_n6894_n2773# sky130_fd_pr__pfet_01v8 ad=0.1421 pd=1.56 as=0.1421 ps=1.56 w=0.49 l=0.2
X575 a_762_118# a_709_247# a_664_118# w_n6894_n2773# sky130_fd_pr__pfet_01v8 ad=0.1421 pd=1.56 as=0.1421 ps=1.56 w=0.49 l=0.2
X576 a_5638_118# a_5585_21# a_5540_118# w_n6894_n2773# sky130_fd_pr__pfet_01v8 ad=0.1421 pd=1.56 as=0.1421 ps=1.56 w=0.49 l=0.2
X577 a_n4962_2456# a_n5015_2585# a_n5060_2456# w_n6894_n2773# sky130_fd_pr__pfet_01v8 ad=0.1421 pd=1.56 as=0.1421 ps=1.56 w=0.49 l=0.2
X578 a_n6446_786# a_n6499_915# a_n6544_786# w_n6894_n2773# sky130_fd_pr__pfet_01v8 ad=0.1421 pd=1.56 as=0.1421 ps=1.56 w=0.49 l=0.2
X579 a_n3478_1788# a_n3531_1691# a_n3576_1788# w_n6894_n2773# sky130_fd_pr__pfet_01v8 ad=0.1421 pd=1.56 as=0.1421 ps=1.56 w=0.49 l=0.2
X580 a_1610_n216# a_1557_n313# a_1512_n216# w_n6894_n2773# sky130_fd_pr__pfet_01v8 ad=0.1421 pd=1.56 as=0.1421 ps=1.56 w=0.49 l=0.2
X581 a_n1994_n2554# a_n2047_n2651# a_n2092_n2554# w_n6894_n2773# sky130_fd_pr__pfet_01v8 ad=0.1421 pd=1.56 as=0.1421 ps=1.56 w=0.49 l=0.2
X582 a_4790_1120# a_4737_1249# a_4692_1120# w_n6894_n2773# sky130_fd_pr__pfet_01v8 ad=0.1421 pd=1.56 as=0.1421 ps=1.56 w=0.49 l=0.2
X583 a_n3478_n2220# a_n3531_n2317# a_n3576_n2220# w_n6894_n2773# sky130_fd_pr__pfet_01v8 ad=0.1421 pd=1.56 as=0.1421 ps=1.56 w=0.49 l=0.2
X584 a_2246_2122# a_2193_2025# a_2148_2122# w_n6894_n2773# sky130_fd_pr__pfet_01v8 ad=0.1421 pd=1.56 as=0.1421 ps=1.56 w=0.49 l=0.2
X585 a_n1782_n1886# a_n1835_n1757# a_n1880_n1886# w_n6894_n2773# sky130_fd_pr__pfet_01v8 ad=0.1421 pd=1.56 as=0.1421 ps=1.56 w=0.49 l=0.2
X586 a_n4962_n884# a_n5015_n755# a_n5060_n884# w_n6894_n2773# sky130_fd_pr__pfet_01v8 ad=0.1421 pd=1.56 as=0.1421 ps=1.56 w=0.49 l=0.2
X587 a_n6446_2122# a_n6499_2251# a_n6544_2122# w_n6894_n2773# sky130_fd_pr__pfet_01v8 ad=0.1421 pd=1.56 as=0.1421 ps=1.56 w=0.49 l=0.2
X588 a_n5810_n550# a_n5863_n647# a_n5908_n550# w_n6894_n2773# sky130_fd_pr__pfet_01v8 ad=0.1421 pd=1.56 as=0.1421 ps=1.56 w=0.49 l=0.2
X589 a_1186_1454# a_1133_1583# a_1088_1454# w_n6894_n2773# sky130_fd_pr__pfet_01v8 ad=0.1421 pd=1.56 as=0.1421 ps=1.56 w=0.49 l=0.2
X590 a_n510_n1218# a_n563_n1089# a_n608_n1218# w_n6894_n2773# sky130_fd_pr__pfet_01v8 ad=0.1421 pd=1.56 as=0.1421 ps=1.56 w=0.49 l=0.2
X591 a_n6234_n550# a_n6287_n647# a_n6332_n550# w_n6894_n2773# sky130_fd_pr__pfet_01v8 ad=0.1421 pd=1.56 as=0.1421 ps=1.56 w=0.49 l=0.2
X592 a_3306_n2554# a_3253_n2425# a_3208_n2554# w_n6894_n2773# sky130_fd_pr__pfet_01v8 ad=0.1421 pd=1.56 as=0.1421 ps=1.56 w=0.49 l=0.2
X593 a_n2842_n1552# a_n2895_n1423# a_n2940_n1552# w_n6894_n2773# sky130_fd_pr__pfet_01v8 ad=0.1421 pd=1.56 as=0.1421 ps=1.56 w=0.49 l=0.2
X594 a_126_n550# a_73_n647# a_28_n550# w_n6894_n2773# sky130_fd_pr__pfet_01v8 ad=0.1421 pd=1.56 as=0.1421 ps=1.56 w=0.49 l=0.2
X595 a_6698_1120# a_6645_1023# a_6600_1120# w_n6894_n2773# sky130_fd_pr__pfet_01v8 ad=0.1421 pd=1.56 as=0.1421 ps=1.56 w=0.49 l=0.2
X596 a_3518_n216# a_3465_n87# a_3420_n216# w_n6894_n2773# sky130_fd_pr__pfet_01v8 ad=0.1421 pd=1.56 as=0.1421 ps=1.56 w=0.49 l=0.2
X597 a_n1782_n550# a_n1835_n421# a_n1880_n550# w_n6894_n2773# sky130_fd_pr__pfet_01v8 ad=0.1421 pd=1.56 as=0.1421 ps=1.56 w=0.49 l=0.2
X598 a_2458_n1218# a_2405_n1089# a_2360_n1218# w_n6894_n2773# sky130_fd_pr__pfet_01v8 ad=0.1421 pd=1.56 as=0.1421 ps=1.56 w=0.49 l=0.2
X599 a_338_n2220# a_285_n2317# a_240_n2220# w_n6894_n2773# sky130_fd_pr__pfet_01v8 ad=0.1421 pd=1.56 as=0.1421 ps=1.56 w=0.49 l=0.2
X600 a_5850_2456# a_5797_2359# a_5752_2456# w_n6894_n2773# sky130_fd_pr__pfet_01v8 ad=0.1421 pd=1.56 as=0.1421 ps=1.56 w=0.49 l=0.2
X601 a_1822_2456# a_1769_2585# a_1724_2456# w_n6894_n2773# sky130_fd_pr__pfet_01v8 ad=0.1421 pd=1.56 as=0.1421 ps=1.56 w=0.49 l=0.2
X602 a_4790_1788# a_4737_1917# a_4692_1788# w_n6894_n2773# sky130_fd_pr__pfet_01v8 ad=0.1421 pd=1.56 as=0.1421 ps=1.56 w=0.49 l=0.2
X603 a_2670_1120# a_2617_1249# a_2572_1120# w_n6894_n2773# sky130_fd_pr__pfet_01v8 ad=0.1421 pd=1.56 as=0.1421 ps=1.56 w=0.49 l=0.2
X604 a_n3266_n2220# a_n3319_n2091# a_n3364_n2220# w_n6894_n2773# sky130_fd_pr__pfet_01v8 ad=0.1421 pd=1.56 as=0.1421 ps=1.56 w=0.49 l=0.2
X605 a_5850_n884# a_5797_n981# a_5752_n884# w_n6894_n2773# sky130_fd_pr__pfet_01v8 ad=0.1421 pd=1.56 as=0.1421 ps=1.56 w=0.49 l=0.2
X606 a_1822_n884# a_1769_n755# a_1724_n884# w_n6894_n2773# sky130_fd_pr__pfet_01v8 ad=0.1421 pd=1.56 as=0.1421 ps=1.56 w=0.49 l=0.2
X607 a_n4326_2122# a_n4379_2251# a_n4424_2122# w_n6894_n2773# sky130_fd_pr__pfet_01v8 ad=0.1421 pd=1.56 as=0.1421 ps=1.56 w=0.49 l=0.2
X608 a_n3902_452# a_n3955_355# a_n4000_452# w_n6894_n2773# sky130_fd_pr__pfet_01v8 ad=0.1421 pd=1.56 as=0.1421 ps=1.56 w=0.49 l=0.2
X609 a_n3690_n550# a_n3743_n647# a_n3788_n550# w_n6894_n2773# sky130_fd_pr__pfet_01v8 ad=0.1421 pd=1.56 as=0.1421 ps=1.56 w=0.49 l=0.2
X610 a_3942_n2554# a_3889_n2651# a_3844_n2554# w_n6894_n2773# sky130_fd_pr__pfet_01v8 ad=0.1421 pd=1.56 as=0.1421 ps=1.56 w=0.49 l=0.2
X611 a_n298_n1218# a_n351_n1315# a_n396_n1218# w_n6894_n2773# sky130_fd_pr__pfet_01v8 ad=0.1421 pd=1.56 as=0.1421 ps=1.56 w=0.49 l=0.2
X612 a_2882_118# a_2829_247# a_2784_118# w_n6894_n2773# sky130_fd_pr__pfet_01v8 ad=0.1421 pd=1.56 as=0.1421 ps=1.56 w=0.49 l=0.2
X613 a_n4114_n550# a_n4167_n647# a_n4212_n550# w_n6894_n2773# sky130_fd_pr__pfet_01v8 ad=0.1421 pd=1.56 as=0.1421 ps=1.56 w=0.49 l=0.2
X614 a_n934_n1886# a_n987_n1757# a_n1032_n1886# w_n6894_n2773# sky130_fd_pr__pfet_01v8 ad=0.1421 pd=1.56 as=0.1421 ps=1.56 w=0.49 l=0.2
X615 a_974_n2220# a_921_n2091# a_876_n2220# w_n6894_n2773# sky130_fd_pr__pfet_01v8 ad=0.1421 pd=1.56 as=0.1421 ps=1.56 w=0.49 l=0.2
X616 a_3094_n2554# a_3041_n2651# a_2996_n2554# w_n6894_n2773# sky130_fd_pr__pfet_01v8 ad=0.1421 pd=1.56 as=0.1421 ps=1.56 w=0.49 l=0.2
X617 a_n5810_n1886# a_n5863_n1983# a_n5908_n1886# w_n6894_n2773# sky130_fd_pr__pfet_01v8 ad=0.1421 pd=1.56 as=0.1421 ps=1.56 w=0.49 l=0.2
X618 a_5850_786# a_5797_915# a_5752_786# w_n6894_n2773# sky130_fd_pr__pfet_01v8 ad=0.1421 pd=1.56 as=0.1421 ps=1.56 w=0.49 l=0.2
X619 a_4578_n2220# a_4525_n2317# a_4480_n2220# w_n6894_n2773# sky130_fd_pr__pfet_01v8 ad=0.1421 pd=1.56 as=0.1421 ps=1.56 w=0.49 l=0.2
X620 a_6698_1788# a_6645_1691# a_6600_1788# w_n6894_n2773# sky130_fd_pr__pfet_01v8 ad=0.1421 pd=1.56 as=0.1421 ps=1.56 w=0.49 l=0.2
X621 a_4578_1120# a_4525_1023# a_4480_1120# w_n6894_n2773# sky130_fd_pr__pfet_01v8 ad=0.1421 pd=1.56 as=0.1421 ps=1.56 w=0.49 l=0.2
X622 a_1398_n216# a_1345_n87# a_1300_n216# w_n6894_n2773# sky130_fd_pr__pfet_01v8 ad=0.1421 pd=1.56 as=0.1421 ps=1.56 w=0.49 l=0.2
X623 a_2882_n1886# a_2829_n1757# a_2784_n1886# w_n6894_n2773# sky130_fd_pr__pfet_01v8 ad=0.1421 pd=1.56 as=0.1421 ps=1.56 w=0.49 l=0.2
X624 a_2246_n1218# a_2193_n1315# a_2148_n1218# w_n6894_n2773# sky130_fd_pr__pfet_01v8 ad=0.1421 pd=1.56 as=0.1421 ps=1.56 w=0.49 l=0.2
X625 a_4790_452# a_4737_581# a_4692_452# w_n6894_n2773# sky130_fd_pr__pfet_01v8 ad=0.1421 pd=1.56 as=0.1421 ps=1.56 w=0.49 l=0.2
X626 a_2670_1788# a_2617_1917# a_2572_1788# w_n6894_n2773# sky130_fd_pr__pfet_01v8 ad=0.1421 pd=1.56 as=0.1421 ps=1.56 w=0.49 l=0.2
X627 a_1610_118# a_1557_247# a_1512_118# w_n6894_n2773# sky130_fd_pr__pfet_01v8 ad=0.1421 pd=1.56 as=0.1421 ps=1.56 w=0.49 l=0.2
X628 a_n2206_2122# a_n2259_2251# a_n2304_2122# w_n6894_n2773# sky130_fd_pr__pfet_01v8 ad=0.1421 pd=1.56 as=0.1421 ps=1.56 w=0.49 l=0.2
X629 a_n1570_n550# a_n1623_n647# a_n1668_n550# w_n6894_n2773# sky130_fd_pr__pfet_01v8 ad=0.1421 pd=1.56 as=0.1421 ps=1.56 w=0.49 l=0.2
X630 a_338_n550# a_285_n421# a_240_n550# w_n6894_n2773# sky130_fd_pr__pfet_01v8 ad=0.1421 pd=1.56 as=0.1421 ps=1.56 w=0.49 l=0.2
X631 a_n1570_118# a_n1623_21# a_n1668_118# w_n6894_n2773# sky130_fd_pr__pfet_01v8 ad=0.1421 pd=1.56 as=0.1421 ps=1.56 w=0.49 l=0.2
X632 a_2034_118# a_1981_247# a_1936_118# w_n6894_n2773# sky130_fd_pr__pfet_01v8 ad=0.1421 pd=1.56 as=0.1421 ps=1.56 w=0.49 l=0.2
X633 a_5002_n550# a_4949_n421# a_4904_n550# w_n6894_n2773# sky130_fd_pr__pfet_01v8 ad=0.1421 pd=1.56 as=0.1421 ps=1.56 w=0.49 l=0.2
X634 a_n722_n1886# a_n775_n1983# a_n820_n1886# w_n6894_n2773# sky130_fd_pr__pfet_01v8 ad=0.1421 pd=1.56 as=0.1421 ps=1.56 w=0.49 l=0.2
X635 a_n86_n1218# a_n139_n1089# a_n184_n1218# w_n6894_n2773# sky130_fd_pr__pfet_01v8 ad=0.1421 pd=1.56 as=0.1421 ps=1.56 w=0.49 l=0.2
X636 a_n1994_n550# a_n2047_n647# a_n2092_n550# w_n6894_n2773# sky130_fd_pr__pfet_01v8 ad=0.1421 pd=1.56 as=0.1421 ps=1.56 w=0.49 l=0.2
X637 a_550_2122# a_497_2025# a_452_2122# w_n6894_n2773# sky130_fd_pr__pfet_01v8 ad=0.1421 pd=1.56 as=0.1421 ps=1.56 w=0.49 l=0.2
X638 a_n5174_1454# a_n5227_1583# a_n5272_1454# w_n6894_n2773# sky130_fd_pr__pfet_01v8 ad=0.1421 pd=1.56 as=0.1421 ps=1.56 w=0.49 l=0.2
X639 a_n1146_1454# a_n1199_1357# a_n1244_1454# w_n6894_n2773# sky130_fd_pr__pfet_01v8 ad=0.1421 pd=1.56 as=0.1421 ps=1.56 w=0.49 l=0.2
X640 a_5002_786# a_4949_915# a_4904_786# w_n6894_n2773# sky130_fd_pr__pfet_01v8 ad=0.1421 pd=1.56 as=0.1421 ps=1.56 w=0.49 l=0.2
X641 a_762_n2220# a_709_n2317# a_664_n2220# w_n6894_n2773# sky130_fd_pr__pfet_01v8 ad=0.1421 pd=1.56 as=0.1421 ps=1.56 w=0.49 l=0.2
X642 a_n5598_n1886# a_n5651_n1757# a_n5696_n1886# w_n6894_n2773# sky130_fd_pr__pfet_01v8 ad=0.1421 pd=1.56 as=0.1421 ps=1.56 w=0.49 l=0.2
X643 a_n298_2122# a_n351_2025# a_n396_2122# w_n6894_n2773# sky130_fd_pr__pfet_01v8 ad=0.1421 pd=1.56 as=0.1421 ps=1.56 w=0.49 l=0.2
X644 a_n2842_786# a_n2895_689# a_n2940_786# w_n6894_n2773# sky130_fd_pr__pfet_01v8 ad=0.1421 pd=1.56 as=0.1421 ps=1.56 w=0.49 l=0.2
X645 a_4366_n2220# a_4313_n2091# a_4268_n2220# w_n6894_n2773# sky130_fd_pr__pfet_01v8 ad=0.1421 pd=1.56 as=0.1421 ps=1.56 w=0.49 l=0.2
X646 a_n3902_n1218# a_n3955_n1089# a_n4000_n1218# w_n6894_n2773# sky130_fd_pr__pfet_01v8 ad=0.1421 pd=1.56 as=0.1421 ps=1.56 w=0.49 l=0.2
X647 a_6062_2456# a_6009_2585# a_5964_2456# w_n6894_n2773# sky130_fd_pr__pfet_01v8 ad=0.1421 pd=1.56 as=0.1421 ps=1.56 w=0.49 l=0.2
X648 a_4578_1788# a_4525_1691# a_4480_1788# w_n6894_n2773# sky130_fd_pr__pfet_01v8 ad=0.1421 pd=1.56 as=0.1421 ps=1.56 w=0.49 l=0.2
X649 a_2458_1120# a_2405_1023# a_2360_1120# w_n6894_n2773# sky130_fd_pr__pfet_01v8 ad=0.1421 pd=1.56 as=0.1421 ps=1.56 w=0.49 l=0.2
X650 a_2670_n1886# a_2617_n1983# a_2572_n1886# w_n6894_n2773# sky130_fd_pr__pfet_01v8 ad=0.1421 pd=1.56 as=0.1421 ps=1.56 w=0.49 l=0.2
X651 a_n3478_452# a_n3531_355# a_n3576_452# w_n6894_n2773# sky130_fd_pr__pfet_01v8 ad=0.1421 pd=1.56 as=0.1421 ps=1.56 w=0.49 l=0.2
X652 a_n86_n550# a_n139_n421# a_n184_n550# w_n6894_n2773# sky130_fd_pr__pfet_01v8 ad=0.1421 pd=1.56 as=0.1421 ps=1.56 w=0.49 l=0.2
X653 a_n6658_1120# a_n6711_1249# a_n6756_1120# w_n6894_n2773# sky130_fd_pr__pfet_01v8 ad=0.1421 pd=1.56 as=0.1421 ps=1.56 w=0.49 l=0.2
X654 a_n6658_n1552# a_n6711_n1423# a_n6756_n1552# w_n6894_n2773# sky130_fd_pr__pfet_01v8 ad=0.1421 pd=1.56 as=0.1421 ps=1.56 w=0.49 l=0.2
X655 a_n3054_n1218# a_n3107_n1089# a_n3152_n1218# w_n6894_n2773# sky130_fd_pr__pfet_01v8 ad=0.1421 pd=1.56 as=0.1421 ps=1.56 w=0.49 l=0.2
X656 a_6062_n884# a_6009_n755# a_5964_n884# w_n6894_n2773# sky130_fd_pr__pfet_01v8 ad=0.1421 pd=1.56 as=0.1421 ps=1.56 w=0.49 l=0.2
X657 a_2458_118# a_2405_247# a_2360_118# w_n6894_n2773# sky130_fd_pr__pfet_01v8 ad=0.1421 pd=1.56 as=0.1421 ps=1.56 w=0.49 l=0.2
X658 a_3730_n1552# a_3677_n1649# a_3632_n1552# w_n6894_n2773# sky130_fd_pr__pfet_01v8 ad=0.1421 pd=1.56 as=0.1421 ps=1.56 w=0.49 l=0.2
X659 a_n3266_786# a_n3319_689# a_n3364_786# w_n6894_n2773# sky130_fd_pr__pfet_01v8 ad=0.1421 pd=1.56 as=0.1421 ps=1.56 w=0.49 l=0.2
X660 a_3730_786# a_3677_915# a_3632_786# w_n6894_n2773# sky130_fd_pr__pfet_01v8 ad=0.1421 pd=1.56 as=0.1421 ps=1.56 w=0.49 l=0.2
X661 a_n3690_786# a_n3743_689# a_n3788_786# w_n6894_n2773# sky130_fd_pr__pfet_01v8 ad=0.1421 pd=1.56 as=0.1421 ps=1.56 w=0.49 l=0.2
X662 a_4366_452# a_4313_581# a_4268_452# w_n6894_n2773# sky130_fd_pr__pfet_01v8 ad=0.1421 pd=1.56 as=0.1421 ps=1.56 w=0.49 l=0.2
X663 a_2882_n550# a_2829_n421# a_2784_n550# w_n6894_n2773# sky130_fd_pr__pfet_01v8 ad=0.1421 pd=1.56 as=0.1421 ps=1.56 w=0.49 l=0.2
X664 a_2034_1454# a_1981_1583# a_1936_1454# w_n6894_n2773# sky130_fd_pr__pfet_01v8 ad=0.1421 pd=1.56 as=0.1421 ps=1.56 w=0.49 l=0.2
X665 a_n2206_452# a_n2259_355# a_n2304_452# w_n6894_n2773# sky130_fd_pr__pfet_01v8 ad=0.1421 pd=1.56 as=0.1421 ps=1.56 w=0.49 l=0.2
X666 a_550_n2220# a_497_n2091# a_452_n2220# w_n6894_n2773# sky130_fd_pr__pfet_01v8 ad=0.1421 pd=1.56 as=0.1421 ps=1.56 w=0.49 l=0.2
X667 a_n5386_n1886# a_n5439_n1983# a_n5484_n1886# w_n6894_n2773# sky130_fd_pr__pfet_01v8 ad=0.1421 pd=1.56 as=0.1421 ps=1.56 w=0.49 l=0.2
X668 a_n722_1120# a_n775_1249# a_n820_1120# w_n6894_n2773# sky130_fd_pr__pfet_01v8 ad=0.1421 pd=1.56 as=0.1421 ps=1.56 w=0.49 l=0.2
X669 a_1186_118# a_1133_247# a_1088_118# w_n6894_n2773# sky130_fd_pr__pfet_01v8 ad=0.1421 pd=1.56 as=0.1421 ps=1.56 w=0.49 l=0.2
X670 a_4154_n2220# a_4101_n2317# a_4056_n2220# w_n6894_n2773# sky130_fd_pr__pfet_01v8 ad=0.1421 pd=1.56 as=0.1421 ps=1.56 w=0.49 l=0.2
X671 a_2458_1788# a_2405_1691# a_2360_1788# w_n6894_n2773# sky130_fd_pr__pfet_01v8 ad=0.1421 pd=1.56 as=0.1421 ps=1.56 w=0.49 l=0.2
X672 a_n2630_452# a_n2683_355# a_n2728_452# w_n6894_n2773# sky130_fd_pr__pfet_01v8 ad=0.1421 pd=1.56 as=0.1421 ps=1.56 w=0.49 l=0.2
X673 a_126_n1886# a_73_n1983# a_28_n1886# w_n6894_n2773# sky130_fd_pr__pfet_01v8 ad=0.1421 pd=1.56 as=0.1421 ps=1.56 w=0.49 l=0.2
X674 a_4154_786# a_4101_915# a_4056_786# w_n6894_n2773# sky130_fd_pr__pfet_01v8 ad=0.1421 pd=1.56 as=0.1421 ps=1.56 w=0.49 l=0.2
X675 a_n5386_n216# a_n5439_n87# a_n5484_n216# w_n6894_n2773# sky130_fd_pr__pfet_01v8 ad=0.1421 pd=1.56 as=0.1421 ps=1.56 w=0.49 l=0.2
X676 a_n1358_n216# a_n1411_n313# a_n1456_n216# w_n6894_n2773# sky130_fd_pr__pfet_01v8 ad=0.1421 pd=1.56 as=0.1421 ps=1.56 w=0.49 l=0.2
X677 a_n6658_1788# a_n6711_1917# a_n6756_1788# w_n6894_n2773# sky130_fd_pr__pfet_01v8 ad=0.1421 pd=1.56 as=0.1421 ps=1.56 w=0.49 l=0.2
X678 a_n4538_1120# a_n4591_1249# a_n4636_1120# w_n6894_n2773# sky130_fd_pr__pfet_01v8 ad=0.1421 pd=1.56 as=0.1421 ps=1.56 w=0.49 l=0.2
X679 a_n1994_786# a_n2047_689# a_n2092_786# w_n6894_n2773# sky130_fd_pr__pfet_01v8 ad=0.1421 pd=1.56 as=0.1421 ps=1.56 w=0.49 l=0.2
X680 a_n6446_n1552# a_n6499_n1649# a_n6544_n1552# w_n6894_n2773# sky130_fd_pr__pfet_01v8 ad=0.1421 pd=1.56 as=0.1421 ps=1.56 w=0.49 l=0.2
X681 a_338_786# a_285_915# a_240_786# w_n6894_n2773# sky130_fd_pr__pfet_01v8 ad=0.1421 pd=1.56 as=0.1421 ps=1.56 w=0.49 l=0.2
X682 a_5426_2122# a_5373_2251# a_5328_2122# w_n6894_n2773# sky130_fd_pr__pfet_01v8 ad=0.1421 pd=1.56 as=0.1421 ps=1.56 w=0.49 l=0.2
X683 a_4578_786# a_4525_915# a_4480_786# w_n6894_n2773# sky130_fd_pr__pfet_01v8 ad=0.1421 pd=1.56 as=0.1421 ps=1.56 w=0.49 l=0.2
X684 a_6698_n1886# a_6645_n1757# a_6600_n1886# w_n6894_n2773# sky130_fd_pr__pfet_01v8 ad=0.1421 pd=1.56 as=0.1421 ps=1.56 w=0.49 l=0.2
X685 a_n2418_786# a_n2471_689# a_n2516_786# w_n6894_n2773# sky130_fd_pr__pfet_01v8 ad=0.1421 pd=1.56 as=0.1421 ps=1.56 w=0.49 l=0.2
X686 a_3094_452# a_3041_581# a_2996_452# w_n6894_n2773# sky130_fd_pr__pfet_01v8 ad=0.1421 pd=1.56 as=0.1421 ps=1.56 w=0.49 l=0.2
X687 a_n1358_n2554# a_n1411_n2425# a_n1456_n2554# w_n6894_n2773# sky130_fd_pr__pfet_01v8 ad=0.1421 pd=1.56 as=0.1421 ps=1.56 w=0.49 l=0.2
X688 a_5002_n1218# a_4949_n1089# a_4904_n1218# w_n6894_n2773# sky130_fd_pr__pfet_01v8 ad=0.1421 pd=1.56 as=0.1421 ps=1.56 w=0.49 l=0.2
X689 a_5214_n550# a_5161_n647# a_5116_n550# w_n6894_n2773# sky130_fd_pr__pfet_01v8 ad=0.1421 pd=1.56 as=0.1421 ps=1.56 w=0.49 l=0.2
X690 a_3518_452# a_3465_581# a_3420_452# w_n6894_n2773# sky130_fd_pr__pfet_01v8 ad=0.1421 pd=1.56 as=0.1421 ps=1.56 w=0.49 l=0.2
X691 a_n1358_452# a_n1411_355# a_n1456_452# w_n6894_n2773# sky130_fd_pr__pfet_01v8 ad=0.1421 pd=1.56 as=0.1421 ps=1.56 w=0.49 l=0.2
X692 a_3942_1454# a_3889_1357# a_3844_1454# w_n6894_n2773# sky130_fd_pr__pfet_01v8 ad=0.1421 pd=1.56 as=0.1421 ps=1.56 w=0.49 l=0.2
X693 a_n5174_n1886# a_n5227_n1757# a_n5272_n1886# w_n6894_n2773# sky130_fd_pr__pfet_01v8 ad=0.1421 pd=1.56 as=0.1421 ps=1.56 w=0.49 l=0.2
X694 a_n5598_2456# a_n5651_2359# a_n5696_2456# w_n6894_n2773# sky130_fd_pr__pfet_01v8 ad=0.1421 pd=1.56 as=0.1421 ps=1.56 w=0.49 l=0.2
X695 a_n722_1788# a_n775_1917# a_n820_1788# w_n6894_n2773# sky130_fd_pr__pfet_01v8 ad=0.1421 pd=1.56 as=0.1421 ps=1.56 w=0.49 l=0.2
X696 a_3306_786# a_3253_915# a_3208_786# w_n6894_n2773# sky130_fd_pr__pfet_01v8 ad=0.1421 pd=1.56 as=0.1421 ps=1.56 w=0.49 l=0.2
X697 a_n6022_2456# a_n6075_2359# a_n6120_2456# w_n6894_n2773# sky130_fd_pr__pfet_01v8 ad=0.1421 pd=1.56 as=0.1421 ps=1.56 w=0.49 l=0.2
X698 a_n1146_786# a_n1199_689# a_n1244_786# w_n6894_n2773# sky130_fd_pr__pfet_01v8 ad=0.1421 pd=1.56 as=0.1421 ps=1.56 w=0.49 l=0.2
X699 a_n3266_n216# a_n3319_n87# a_n3364_n216# w_n6894_n2773# sky130_fd_pr__pfet_01v8 ad=0.1421 pd=1.56 as=0.1421 ps=1.56 w=0.49 l=0.2
X700 a_n4538_1788# a_n4591_1917# a_n4636_1788# w_n6894_n2773# sky130_fd_pr__pfet_01v8 ad=0.1421 pd=1.56 as=0.1421 ps=1.56 w=0.49 l=0.2
X701 a_n2418_1120# a_n2471_1249# a_n2516_1120# w_n6894_n2773# sky130_fd_pr__pfet_01v8 ad=0.1421 pd=1.56 as=0.1421 ps=1.56 w=0.49 l=0.2
X702 a_n6234_n1552# a_n6287_n1423# a_n6332_n1552# w_n6894_n2773# sky130_fd_pr__pfet_01v8 ad=0.1421 pd=1.56 as=0.1421 ps=1.56 w=0.49 l=0.2
X703 a_n5598_n884# a_n5651_n981# a_n5696_n884# w_n6894_n2773# sky130_fd_pr__pfet_01v8 ad=0.1421 pd=1.56 as=0.1421 ps=1.56 w=0.49 l=0.2
X704 a_3306_2122# a_3253_2251# a_3208_2122# w_n6894_n2773# sky130_fd_pr__pfet_01v8 ad=0.1421 pd=1.56 as=0.1421 ps=1.56 w=0.49 l=0.2
X705 a_762_1120# a_709_1023# a_664_1120# w_n6894_n2773# sky130_fd_pr__pfet_01v8 ad=0.1421 pd=1.56 as=0.1421 ps=1.56 w=0.49 l=0.2
X706 a_n1146_n2554# a_n1199_n2651# a_n1244_n2554# w_n6894_n2773# sky130_fd_pr__pfet_01v8 ad=0.1421 pd=1.56 as=0.1421 ps=1.56 w=0.49 l=0.2
X707 a_6486_n1886# a_6433_n1983# a_6388_n1886# w_n6894_n2773# sky130_fd_pr__pfet_01v8 ad=0.1421 pd=1.56 as=0.1421 ps=1.56 w=0.49 l=0.2
X708 a_n6022_n884# a_n6075_n981# a_n6120_n884# w_n6894_n2773# sky130_fd_pr__pfet_01v8 ad=0.1421 pd=1.56 as=0.1421 ps=1.56 w=0.49 l=0.2
X709 a_4790_n1218# a_4737_n1315# a_4692_n1218# w_n6894_n2773# sky130_fd_pr__pfet_01v8 ad=0.1421 pd=1.56 as=0.1421 ps=1.56 w=0.49 l=0.2
X710 a_6274_1454# a_6221_1583# a_6176_1454# w_n6894_n2773# sky130_fd_pr__pfet_01v8 ad=0.1421 pd=1.56 as=0.1421 ps=1.56 w=0.49 l=0.2
X711 a_n510_1120# a_n563_1023# a_n608_1120# w_n6894_n2773# sky130_fd_pr__pfet_01v8 ad=0.1421 pd=1.56 as=0.1421 ps=1.56 w=0.49 l=0.2
X712 a_3094_n550# a_3041_n647# a_2996_n550# w_n6894_n2773# sky130_fd_pr__pfet_01v8 ad=0.1421 pd=1.56 as=0.1421 ps=1.56 w=0.49 l=0.2
X713 a_n2630_n2220# a_n2683_n2317# a_n2728_n2220# w_n6894_n2773# sky130_fd_pr__pfet_01v8 ad=0.1421 pd=1.56 as=0.1421 ps=1.56 w=0.49 l=0.2
X714 a_n2842_n550# a_n2895_n647# a_n2940_n550# w_n6894_n2773# sky130_fd_pr__pfet_01v8 ad=0.1421 pd=1.56 as=0.1421 ps=1.56 w=0.49 l=0.2
X715 a_n4962_n1886# a_n5015_n1983# a_n5060_n1886# w_n6894_n2773# sky130_fd_pr__pfet_01v8 ad=0.1421 pd=1.56 as=0.1421 ps=1.56 w=0.49 l=0.2
X716 a_n3478_2456# a_n3531_2359# a_n3576_2456# w_n6894_n2773# sky130_fd_pr__pfet_01v8 ad=0.1421 pd=1.56 as=0.1421 ps=1.56 w=0.49 l=0.2
X717 a_n3478_n884# a_n3531_n981# a_n3576_n884# w_n6894_n2773# sky130_fd_pr__pfet_01v8 ad=0.1421 pd=1.56 as=0.1421 ps=1.56 w=0.49 l=0.2
X718 a_n2418_1788# a_n2471_1917# a_n2516_1788# w_n6894_n2773# sky130_fd_pr__pfet_01v8 ad=0.1421 pd=1.56 as=0.1421 ps=1.56 w=0.49 l=0.2
X719 a_n934_n550# a_n987_n421# a_n1032_n550# w_n6894_n2773# sky130_fd_pr__pfet_01v8 ad=0.1421 pd=1.56 as=0.1421 ps=1.56 w=0.49 l=0.2
X720 a_n1782_n2554# a_n1835_n2425# a_n1880_n2554# w_n6894_n2773# sky130_fd_pr__pfet_01v8 ad=0.1421 pd=1.56 as=0.1421 ps=1.56 w=0.49 l=0.2
X721 a_n6022_n1552# a_n6075_n1649# a_n6120_n1552# w_n6894_n2773# sky130_fd_pr__pfet_01v8 ad=0.1421 pd=1.56 as=0.1421 ps=1.56 w=0.49 l=0.2
X722 a_3730_1120# a_3677_1023# a_3632_1120# w_n6894_n2773# sky130_fd_pr__pfet_01v8 ad=0.1421 pd=1.56 as=0.1421 ps=1.56 w=0.49 l=0.2
X723 a_1186_2122# a_1133_2251# a_1088_2122# w_n6894_n2773# sky130_fd_pr__pfet_01v8 ad=0.1421 pd=1.56 as=0.1421 ps=1.56 w=0.49 l=0.2
X724 a_762_1788# a_709_1691# a_664_1788# w_n6894_n2773# sky130_fd_pr__pfet_01v8 ad=0.1421 pd=1.56 as=0.1421 ps=1.56 w=0.49 l=0.2
X725 a_6274_n1886# a_6221_n1757# a_6176_n1886# w_n6894_n2773# sky130_fd_pr__pfet_01v8 ad=0.1421 pd=1.56 as=0.1421 ps=1.56 w=0.49 l=0.2
X726 a_n4750_n550# a_n4803_n421# a_n4848_n550# w_n6894_n2773# sky130_fd_pr__pfet_01v8 ad=0.1421 pd=1.56 as=0.1421 ps=1.56 w=0.49 l=0.2
X727 a_n510_1788# a_n563_1691# a_n608_1788# w_n6894_n2773# sky130_fd_pr__pfet_01v8 ad=0.1421 pd=1.56 as=0.1421 ps=1.56 w=0.49 l=0.2
X728 a_4154_1454# a_4101_1583# a_4056_1454# w_n6894_n2773# sky130_fd_pr__pfet_01v8 ad=0.1421 pd=1.56 as=0.1421 ps=1.56 w=0.49 l=0.2
X729 a_n2418_n2220# a_n2471_n2091# a_n2516_n2220# w_n6894_n2773# sky130_fd_pr__pfet_01v8 ad=0.1421 pd=1.56 as=0.1421 ps=1.56 w=0.49 l=0.2
X730 a_n3690_n1552# a_n3743_n1423# a_n3788_n1552# w_n6894_n2773# sky130_fd_pr__pfet_01v8 ad=0.1421 pd=1.56 as=0.1421 ps=1.56 w=0.49 l=0.2
X731 a_6486_n216# a_6433_n87# a_6388_n216# w_n6894_n2773# sky130_fd_pr__pfet_01v8 ad=0.1421 pd=1.56 as=0.1421 ps=1.56 w=0.49 l=0.2
X732 a_n3902_1454# a_n3955_1583# a_n4000_1454# w_n6894_n2773# sky130_fd_pr__pfet_01v8 ad=0.1421 pd=1.56 as=0.1421 ps=1.56 w=0.49 l=0.2
X733 a_5638_1120# a_5585_1249# a_5540_1120# w_n6894_n2773# sky130_fd_pr__pfet_01v8 ad=0.1421 pd=1.56 as=0.1421 ps=1.56 w=0.49 l=0.2
X734 a_4790_2456# a_4737_2585# a_4692_2456# w_n6894_n2773# sky130_fd_pr__pfet_01v8 ad=0.1421 pd=1.56 as=0.1421 ps=1.56 w=0.49 l=0.2
X735 a_1398_n1218# a_1345_n1315# a_1300_n1218# w_n6894_n2773# sky130_fd_pr__pfet_01v8 ad=0.1421 pd=1.56 as=0.1421 ps=1.56 w=0.49 l=0.2
X736 a_2034_n1886# a_1981_n1757# a_1936_n1886# w_n6894_n2773# sky130_fd_pr__pfet_01v8 ad=0.1421 pd=1.56 as=0.1421 ps=1.56 w=0.49 l=0.2
X737 a_3730_1788# a_3677_1691# a_3632_1788# w_n6894_n2773# sky130_fd_pr__pfet_01v8 ad=0.1421 pd=1.56 as=0.1421 ps=1.56 w=0.49 l=0.2
X738 a_1610_1120# a_1557_1023# a_1512_1120# w_n6894_n2773# sky130_fd_pr__pfet_01v8 ad=0.1421 pd=1.56 as=0.1421 ps=1.56 w=0.49 l=0.2
X739 a_4790_n884# a_4737_n755# a_4692_n884# w_n6894_n2773# sky130_fd_pr__pfet_01v8 ad=0.1421 pd=1.56 as=0.1421 ps=1.56 w=0.49 l=0.2
X740 a_n934_n2554# a_n987_n2425# a_n1032_n2554# w_n6894_n2773# sky130_fd_pr__pfet_01v8 ad=0.1421 pd=1.56 as=0.1421 ps=1.56 w=0.49 l=0.2
X741 a_6062_n1886# a_6009_n1983# a_5964_n1886# w_n6894_n2773# sky130_fd_pr__pfet_01v8 ad=0.1421 pd=1.56 as=0.1421 ps=1.56 w=0.49 l=0.2
X742 a_n2630_n550# a_n2683_n421# a_n2728_n550# w_n6894_n2773# sky130_fd_pr__pfet_01v8 ad=0.1421 pd=1.56 as=0.1421 ps=1.56 w=0.49 l=0.2
X743 a_n5810_n2554# a_n5863_n2651# a_n5908_n2554# w_n6894_n2773# sky130_fd_pr__pfet_01v8 ad=0.1421 pd=1.56 as=0.1421 ps=1.56 w=0.49 l=0.2
X744 a_n2206_n2220# a_n2259_n2317# a_n2304_n2220# w_n6894_n2773# sky130_fd_pr__pfet_01v8 ad=0.1421 pd=1.56 as=0.1421 ps=1.56 w=0.49 l=0.2
X745 a_n5810_1454# a_n5863_1357# a_n5908_1454# w_n6894_n2773# sky130_fd_pr__pfet_01v8 ad=0.1421 pd=1.56 as=0.1421 ps=1.56 w=0.49 l=0.2
X746 a_n3478_n1552# a_n3531_n1649# a_n3576_n1552# w_n6894_n2773# sky130_fd_pr__pfet_01v8 ad=0.1421 pd=1.56 as=0.1421 ps=1.56 w=0.49 l=0.2
X747 a_n934_452# a_n987_355# a_n1032_452# w_n6894_n2773# sky130_fd_pr__pfet_01v8 ad=0.1421 pd=1.56 as=0.1421 ps=1.56 w=0.49 l=0.2
X748 a_n3054_n550# a_n3107_n421# a_n3152_n550# w_n6894_n2773# sky130_fd_pr__pfet_01v8 ad=0.1421 pd=1.56 as=0.1421 ps=1.56 w=0.49 l=0.2
X749 a_2882_n2554# a_2829_n2425# a_2784_n2554# w_n6894_n2773# sky130_fd_pr__pfet_01v8 ad=0.1421 pd=1.56 as=0.1421 ps=1.56 w=0.49 l=0.2
X750 a_6698_2456# a_6645_2359# a_6600_2456# w_n6894_n2773# sky130_fd_pr__pfet_01v8 ad=0.1421 pd=1.56 as=0.1421 ps=1.56 w=0.49 l=0.2
X751 a_n6234_1454# a_n6287_1357# a_n6332_1454# w_n6894_n2773# sky130_fd_pr__pfet_01v8 ad=0.1421 pd=1.56 as=0.1421 ps=1.56 w=0.49 l=0.2
X752 a_974_n550# a_921_n647# a_876_n550# w_n6894_n2773# sky130_fd_pr__pfet_01v8 ad=0.1421 pd=1.56 as=0.1421 ps=1.56 w=0.49 l=0.2
X753 a_n6234_118# a_n6287_21# a_n6332_118# w_n6894_n2773# sky130_fd_pr__pfet_01v8 ad=0.1421 pd=1.56 as=0.1421 ps=1.56 w=0.49 l=0.2
X754 a_4366_n216# a_4313_n87# a_4268_n216# w_n6894_n2773# sky130_fd_pr__pfet_01v8 ad=0.1421 pd=1.56 as=0.1421 ps=1.56 w=0.49 l=0.2
X755 a_n1782_1454# a_n1835_1583# a_n1880_1454# w_n6894_n2773# sky130_fd_pr__pfet_01v8 ad=0.1421 pd=1.56 as=0.1421 ps=1.56 w=0.49 l=0.2
X756 a_126_1454# a_73_1357# a_28_1454# w_n6894_n2773# sky130_fd_pr__pfet_01v8 ad=0.1421 pd=1.56 as=0.1421 ps=1.56 w=0.49 l=0.2
X757 a_3518_1120# a_3465_1249# a_3420_1120# w_n6894_n2773# sky130_fd_pr__pfet_01v8 ad=0.1421 pd=1.56 as=0.1421 ps=1.56 w=0.49 l=0.2
X758 a_n4750_n1886# a_n4803_n1757# a_n4848_n1886# w_n6894_n2773# sky130_fd_pr__pfet_01v8 ad=0.1421 pd=1.56 as=0.1421 ps=1.56 w=0.49 l=0.2
X759 a_6698_n884# a_6645_n981# a_6600_n884# w_n6894_n2773# sky130_fd_pr__pfet_01v8 ad=0.1421 pd=1.56 as=0.1421 ps=1.56 w=0.49 l=0.2
X760 a_5638_1788# a_5585_1917# a_5540_1788# w_n6894_n2773# sky130_fd_pr__pfet_01v8 ad=0.1421 pd=1.56 as=0.1421 ps=1.56 w=0.49 l=0.2
X761 a_3518_n2220# a_3465_n2091# a_3420_n2220# w_n6894_n2773# sky130_fd_pr__pfet_01v8 ad=0.1421 pd=1.56 as=0.1421 ps=1.56 w=0.49 l=0.2
X762 a_2670_2456# a_2617_2585# a_2572_2456# w_n6894_n2773# sky130_fd_pr__pfet_01v8 ad=0.1421 pd=1.56 as=0.1421 ps=1.56 w=0.49 l=0.2
X763 a_n722_786# a_n775_689# a_n820_786# w_n6894_n2773# sky130_fd_pr__pfet_01v8 ad=0.1421 pd=1.56 as=0.1421 ps=1.56 w=0.49 l=0.2
X764 a_n6658_118# a_n6711_21# a_n6756_118# w_n6894_n2773# sky130_fd_pr__pfet_01v8 ad=0.1421 pd=1.56 as=0.1421 ps=1.56 w=0.49 l=0.2
X765 a_1186_n1218# a_1133_n1089# a_1088_n1218# w_n6894_n2773# sky130_fd_pr__pfet_01v8 ad=0.1421 pd=1.56 as=0.1421 ps=1.56 w=0.49 l=0.2
X766 a_1822_n1886# a_1769_n1983# a_1724_n1886# w_n6894_n2773# sky130_fd_pr__pfet_01v8 ad=0.1421 pd=1.56 as=0.1421 ps=1.56 w=0.49 l=0.2
X767 a_338_n1552# a_285_n1649# a_240_n1552# w_n6894_n2773# sky130_fd_pr__pfet_01v8 ad=0.1421 pd=1.56 as=0.1421 ps=1.56 w=0.49 l=0.2
X768 a_1610_1788# a_1557_1691# a_1512_1788# w_n6894_n2773# sky130_fd_pr__pfet_01v8 ad=0.1421 pd=1.56 as=0.1421 ps=1.56 w=0.49 l=0.2
X769 a_2670_n884# a_2617_n755# a_2572_n884# w_n6894_n2773# sky130_fd_pr__pfet_01v8 ad=0.1421 pd=1.56 as=0.1421 ps=1.56 w=0.49 l=0.2
X770 a_n722_n2554# a_n775_n2651# a_n820_n2554# w_n6894_n2773# sky130_fd_pr__pfet_01v8 ad=0.1421 pd=1.56 as=0.1421 ps=1.56 w=0.49 l=0.2
X771 a_n5174_2122# a_n5227_2251# a_n5272_2122# w_n6894_n2773# sky130_fd_pr__pfet_01v8 ad=0.1421 pd=1.56 as=0.1421 ps=1.56 w=0.49 l=0.2
X772 a_n1146_2122# a_n1199_2025# a_n1244_2122# w_n6894_n2773# sky130_fd_pr__pfet_01v8 ad=0.1421 pd=1.56 as=0.1421 ps=1.56 w=0.49 l=0.2
X773 a_n5598_n2554# a_n5651_n2425# a_n5696_n2554# w_n6894_n2773# sky130_fd_pr__pfet_01v8 ad=0.1421 pd=1.56 as=0.1421 ps=1.56 w=0.49 l=0.2
X774 a_n1994_n2220# a_n2047_n2091# a_n2092_n2220# w_n6894_n2773# sky130_fd_pr__pfet_01v8 ad=0.1421 pd=1.56 as=0.1421 ps=1.56 w=0.49 l=0.2
X775 a_n3690_1454# a_n3743_1357# a_n3788_1454# w_n6894_n2773# sky130_fd_pr__pfet_01v8 ad=0.1421 pd=1.56 as=0.1421 ps=1.56 w=0.49 l=0.2
X776 a_n3266_n1552# a_n3319_n1423# a_n3364_n1552# w_n6894_n2773# sky130_fd_pr__pfet_01v8 ad=0.1421 pd=1.56 as=0.1421 ps=1.56 w=0.49 l=0.2
X777 a_n4962_n550# a_n5015_n647# a_n5060_n550# w_n6894_n2773# sky130_fd_pr__pfet_01v8 ad=0.1421 pd=1.56 as=0.1421 ps=1.56 w=0.49 l=0.2
X778 a_2670_n2554# a_2617_n2651# a_2572_n2554# w_n6894_n2773# sky130_fd_pr__pfet_01v8 ad=0.1421 pd=1.56 as=0.1421 ps=1.56 w=0.49 l=0.2
X779 a_4578_2456# a_4525_2359# a_4480_2456# w_n6894_n2773# sky130_fd_pr__pfet_01v8 ad=0.1421 pd=1.56 as=0.1421 ps=1.56 w=0.49 l=0.2
X780 a_n4114_1454# a_n4167_1357# a_n4212_1454# w_n6894_n2773# sky130_fd_pr__pfet_01v8 ad=0.1421 pd=1.56 as=0.1421 ps=1.56 w=0.49 l=0.2
X781 a_2246_n216# a_2193_n87# a_2148_n216# w_n6894_n2773# sky130_fd_pr__pfet_01v8 ad=0.1421 pd=1.56 as=0.1421 ps=1.56 w=0.49 l=0.2
X782 a_1398_1120# a_1345_1249# a_1300_1120# w_n6894_n2773# sky130_fd_pr__pfet_01v8 ad=0.1421 pd=1.56 as=0.1421 ps=1.56 w=0.49 l=0.2
X783 a_n86_452# a_n139_355# a_n184_452# w_n6894_n2773# sky130_fd_pr__pfet_01v8 ad=0.1421 pd=1.56 as=0.1421 ps=1.56 w=0.49 l=0.2
X784 a_n4538_n1886# a_n4591_n1983# a_n4636_n1886# w_n6894_n2773# sky130_fd_pr__pfet_01v8 ad=0.1421 pd=1.56 as=0.1421 ps=1.56 w=0.49 l=0.2
X785 a_4578_n884# a_4525_n981# a_4480_n884# w_n6894_n2773# sky130_fd_pr__pfet_01v8 ad=0.1421 pd=1.56 as=0.1421 ps=1.56 w=0.49 l=0.2
X786 a_3518_1788# a_3465_1917# a_3420_1788# w_n6894_n2773# sky130_fd_pr__pfet_01v8 ad=0.1421 pd=1.56 as=0.1421 ps=1.56 w=0.49 l=0.2
X787 a_n6446_n216# a_n6499_n313# a_n6544_n216# w_n6894_n2773# sky130_fd_pr__pfet_01v8 ad=0.1421 pd=1.56 as=0.1421 ps=1.56 w=0.49 l=0.2
X788 a_3306_n2220# a_3253_n2317# a_3208_n2220# w_n6894_n2773# sky130_fd_pr__pfet_01v8 ad=0.1421 pd=1.56 as=0.1421 ps=1.56 w=0.49 l=0.2
X789 a_974_n1552# a_921_n1423# a_876_n1552# w_n6894_n2773# sky130_fd_pr__pfet_01v8 ad=0.1421 pd=1.56 as=0.1421 ps=1.56 w=0.49 l=0.2
X790 a_1610_n1886# a_1557_n1757# a_1512_n1886# w_n6894_n2773# sky130_fd_pr__pfet_01v8 ad=0.1421 pd=1.56 as=0.1421 ps=1.56 w=0.49 l=0.2
X791 a_4578_n1552# a_4525_n1649# a_4480_n1552# w_n6894_n2773# sky130_fd_pr__pfet_01v8 ad=0.1421 pd=1.56 as=0.1421 ps=1.56 w=0.49 l=0.2
X792 a_n2842_n1218# a_n2895_n1315# a_n2940_n1218# w_n6894_n2773# sky130_fd_pr__pfet_01v8 ad=0.1421 pd=1.56 as=0.1421 ps=1.56 w=0.49 l=0.2
X793 a_n510_452# a_n563_355# a_n608_452# w_n6894_n2773# sky130_fd_pr__pfet_01v8 ad=0.1421 pd=1.56 as=0.1421 ps=1.56 w=0.49 l=0.2
X794 a_2034_2122# a_1981_2251# a_1936_2122# w_n6894_n2773# sky130_fd_pr__pfet_01v8 ad=0.1421 pd=1.56 as=0.1421 ps=1.56 w=0.49 l=0.2
X795 a_n5386_n2554# a_n5439_n2651# a_n5484_n2554# w_n6894_n2773# sky130_fd_pr__pfet_01v8 ad=0.1421 pd=1.56 as=0.1421 ps=1.56 w=0.49 l=0.2
X796 a_n1570_1454# a_n1623_1357# a_n1668_1454# w_n6894_n2773# sky130_fd_pr__pfet_01v8 ad=0.1421 pd=1.56 as=0.1421 ps=1.56 w=0.49 l=0.2
X797 a_338_1454# a_285_1583# a_240_1454# w_n6894_n2773# sky130_fd_pr__pfet_01v8 ad=0.1421 pd=1.56 as=0.1421 ps=1.56 w=0.49 l=0.2
X798 a_n298_786# a_n351_689# a_n396_786# w_n6894_n2773# sky130_fd_pr__pfet_01v8 ad=0.1421 pd=1.56 as=0.1421 ps=1.56 w=0.49 l=0.2
X799 a_1822_n550# a_1769_n647# a_1724_n550# w_n6894_n2773# sky130_fd_pr__pfet_01v8 ad=0.1421 pd=1.56 as=0.1421 ps=1.56 w=0.49 l=0.2
X800 a_5850_n550# a_5797_n421# a_5752_n550# w_n6894_n2773# sky130_fd_pr__pfet_01v8 ad=0.1421 pd=1.56 as=0.1421 ps=1.56 w=0.49 l=0.2
X801 a_5002_1454# a_4949_1583# a_4904_1454# w_n6894_n2773# sky130_fd_pr__pfet_01v8 ad=0.1421 pd=1.56 as=0.1421 ps=1.56 w=0.49 l=0.2
X802 a_126_n2554# a_73_n2651# a_28_n2554# w_n6894_n2773# sky130_fd_pr__pfet_01v8 ad=0.1421 pd=1.56 as=0.1421 ps=1.56 w=0.49 l=0.2
X803 a_2458_2456# a_2405_2359# a_2360_2456# w_n6894_n2773# sky130_fd_pr__pfet_01v8 ad=0.1421 pd=1.56 as=0.1421 ps=1.56 w=0.49 l=0.2
X804 a_n1994_1454# a_n2047_1357# a_n2092_1454# w_n6894_n2773# sky130_fd_pr__pfet_01v8 ad=0.1421 pd=1.56 as=0.1421 ps=1.56 w=0.49 l=0.2
X805 a_3942_n2220# a_3889_n2091# a_3844_n2220# w_n6894_n2773# sky130_fd_pr__pfet_01v8 ad=0.1421 pd=1.56 as=0.1421 ps=1.56 w=0.49 l=0.2
X806 a_n6658_2456# a_n6711_2585# a_n6756_2456# w_n6894_n2773# sky130_fd_pr__pfet_01v8 ad=0.1421 pd=1.56 as=0.1421 ps=1.56 w=0.49 l=0.2
X807 a_n3902_118# a_n3955_247# a_n4000_118# w_n6894_n2773# sky130_fd_pr__pfet_01v8 ad=0.1421 pd=1.56 as=0.1421 ps=1.56 w=0.49 l=0.2
X808 a_n4326_n1886# a_n4379_n1757# a_n4424_n1886# w_n6894_n2773# sky130_fd_pr__pfet_01v8 ad=0.1421 pd=1.56 as=0.1421 ps=1.56 w=0.49 l=0.2
X809 a_2458_n884# a_2405_n981# a_2360_n884# w_n6894_n2773# sky130_fd_pr__pfet_01v8 ad=0.1421 pd=1.56 as=0.1421 ps=1.56 w=0.49 l=0.2
X810 a_1398_1788# a_1345_1917# a_1300_1788# w_n6894_n2773# sky130_fd_pr__pfet_01v8 ad=0.1421 pd=1.56 as=0.1421 ps=1.56 w=0.49 l=0.2
X811 a_n4326_n216# a_n4379_n313# a_n4424_n216# w_n6894_n2773# sky130_fd_pr__pfet_01v8 ad=0.1421 pd=1.56 as=0.1421 ps=1.56 w=0.49 l=0.2
X812 a_3094_n2220# a_3041_n2091# a_2996_n2220# w_n6894_n2773# sky130_fd_pr__pfet_01v8 ad=0.1421 pd=1.56 as=0.1421 ps=1.56 w=0.49 l=0.2
X813 a_6698_n2554# a_6645_n2425# a_6600_n2554# w_n6894_n2773# sky130_fd_pr__pfet_01v8 ad=0.1421 pd=1.56 as=0.1421 ps=1.56 w=0.49 l=0.2
X814 a_762_n1552# a_709_n1649# a_664_n1552# w_n6894_n2773# sky130_fd_pr__pfet_01v8 ad=0.1421 pd=1.56 as=0.1421 ps=1.56 w=0.49 l=0.2
X815 a_n86_1454# a_n139_1583# a_n184_1454# w_n6894_n2773# sky130_fd_pr__pfet_01v8 ad=0.1421 pd=1.56 as=0.1421 ps=1.56 w=0.49 l=0.2
X816 a_4366_n1552# a_4313_n1423# a_4268_n1552# w_n6894_n2773# sky130_fd_pr__pfet_01v8 ad=0.1421 pd=1.56 as=0.1421 ps=1.56 w=0.49 l=0.2
X817 a_n6658_n884# a_n6711_n755# a_n6756_n884# w_n6894_n2773# sky130_fd_pr__pfet_01v8 ad=0.1421 pd=1.56 as=0.1421 ps=1.56 w=0.49 l=0.2
X818 a_3942_2122# a_3889_2025# a_3844_2122# w_n6894_n2773# sky130_fd_pr__pfet_01v8 ad=0.1421 pd=1.56 as=0.1421 ps=1.56 w=0.49 l=0.2
X819 a_4790_118# a_4737_21# a_4692_118# w_n6894_n2773# sky130_fd_pr__pfet_01v8 ad=0.1421 pd=1.56 as=0.1421 ps=1.56 w=0.49 l=0.2
X820 a_5638_n1886# a_5585_n1983# a_5540_n1886# w_n6894_n2773# sky130_fd_pr__pfet_01v8 ad=0.1421 pd=1.56 as=0.1421 ps=1.56 w=0.49 l=0.2
X821 a_n5174_n2554# a_n5227_n2425# a_n5272_n2554# w_n6894_n2773# sky130_fd_pr__pfet_01v8 ad=0.1421 pd=1.56 as=0.1421 ps=1.56 w=0.49 l=0.2
X822 a_n722_2456# a_n775_2585# a_n820_2456# w_n6894_n2773# sky130_fd_pr__pfet_01v8 ad=0.1421 pd=1.56 as=0.1421 ps=1.56 w=0.49 l=0.2
X823 a_2882_1454# a_2829_1583# a_2784_1454# w_n6894_n2773# sky130_fd_pr__pfet_01v8 ad=0.1421 pd=1.56 as=0.1421 ps=1.56 w=0.49 l=0.2
X824 a_n4538_2456# a_n4591_2585# a_n4636_2456# w_n6894_n2773# sky130_fd_pr__pfet_01v8 ad=0.1421 pd=1.56 as=0.1421 ps=1.56 w=0.49 l=0.2
X825 a_n722_n884# a_n775_n755# a_n820_n884# w_n6894_n2773# sky130_fd_pr__pfet_01v8 ad=0.1421 pd=1.56 as=0.1421 ps=1.56 w=0.49 l=0.2
X826 a_n4114_n1886# a_n4167_n1983# a_n4212_n1886# w_n6894_n2773# sky130_fd_pr__pfet_01v8 ad=0.1421 pd=1.56 as=0.1421 ps=1.56 w=0.49 l=0.2
X827 a_n2206_n216# a_n2259_n313# a_n2304_n216# w_n6894_n2773# sky130_fd_pr__pfet_01v8 ad=0.1421 pd=1.56 as=0.1421 ps=1.56 w=0.49 l=0.2
X828 a_6486_n2554# a_6433_n2651# a_6388_n2554# w_n6894_n2773# sky130_fd_pr__pfet_01v8 ad=0.1421 pd=1.56 as=0.1421 ps=1.56 w=0.49 l=0.2
X829 a_550_n1552# a_497_n1423# a_452_n1552# w_n6894_n2773# sky130_fd_pr__pfet_01v8 ad=0.1421 pd=1.56 as=0.1421 ps=1.56 w=0.49 l=0.2
X830 a_n5386_1120# a_n5439_1249# a_n5484_1120# w_n6894_n2773# sky130_fd_pr__pfet_01v8 ad=0.1421 pd=1.56 as=0.1421 ps=1.56 w=0.49 l=0.2
X831 a_n1358_1120# a_n1411_1023# a_n1456_1120# w_n6894_n2773# sky130_fd_pr__pfet_01v8 ad=0.1421 pd=1.56 as=0.1421 ps=1.56 w=0.49 l=0.2
X832 a_4154_n1552# a_4101_n1649# a_4056_n1552# w_n6894_n2773# sky130_fd_pr__pfet_01v8 ad=0.1421 pd=1.56 as=0.1421 ps=1.56 w=0.49 l=0.2
X833 a_n4538_n884# a_n4591_n755# a_n4636_n884# w_n6894_n2773# sky130_fd_pr__pfet_01v8 ad=0.1421 pd=1.56 as=0.1421 ps=1.56 w=0.49 l=0.2
X834 a_550_n216# a_497_n87# a_452_n216# w_n6894_n2773# sky130_fd_pr__pfet_01v8 ad=0.1421 pd=1.56 as=0.1421 ps=1.56 w=0.49 l=0.2
X835 a_6274_2122# a_6221_2251# a_6176_2122# w_n6894_n2773# sky130_fd_pr__pfet_01v8 ad=0.1421 pd=1.56 as=0.1421 ps=1.56 w=0.49 l=0.2
X836 a_n3478_118# a_n3531_247# a_n3576_118# w_n6894_n2773# sky130_fd_pr__pfet_01v8 ad=0.1421 pd=1.56 as=0.1421 ps=1.56 w=0.49 l=0.2
X837 a_n298_n216# a_n351_n87# a_n396_n216# w_n6894_n2773# sky130_fd_pr__pfet_01v8 ad=0.1421 pd=1.56 as=0.1421 ps=1.56 w=0.49 l=0.2
X838 a_n6658_n1218# a_n6711_n1315# a_n6756_n1218# w_n6894_n2773# sky130_fd_pr__pfet_01v8 ad=0.1421 pd=1.56 as=0.1421 ps=1.56 w=0.49 l=0.2
X839 a_6062_n550# a_6009_n647# a_5964_n550# w_n6894_n2773# sky130_fd_pr__pfet_01v8 ad=0.1421 pd=1.56 as=0.1421 ps=1.56 w=0.49 l=0.2
X840 a_5426_n1886# a_5373_n1757# a_5328_n1886# w_n6894_n2773# sky130_fd_pr__pfet_01v8 ad=0.1421 pd=1.56 as=0.1421 ps=1.56 w=0.49 l=0.2
X841 a_5214_1454# a_5161_1357# a_5116_1454# w_n6894_n2773# sky130_fd_pr__pfet_01v8 ad=0.1421 pd=1.56 as=0.1421 ps=1.56 w=0.49 l=0.2
X842 a_n4962_452# a_n5015_581# a_n5060_452# w_n6894_n2773# sky130_fd_pr__pfet_01v8 ad=0.1421 pd=1.56 as=0.1421 ps=1.56 w=0.49 l=0.2
X843 a_n4962_n2554# a_n5015_n2651# a_n5060_n2554# w_n6894_n2773# sky130_fd_pr__pfet_01v8 ad=0.1421 pd=1.56 as=0.1421 ps=1.56 w=0.49 l=0.2
X844 a_3730_n1218# a_3677_n1089# a_3632_n1218# w_n6894_n2773# sky130_fd_pr__pfet_01v8 ad=0.1421 pd=1.56 as=0.1421 ps=1.56 w=0.49 l=0.2
X845 a_n5386_452# a_n5439_581# a_n5484_452# w_n6894_n2773# sky130_fd_pr__pfet_01v8 ad=0.1421 pd=1.56 as=0.1421 ps=1.56 w=0.49 l=0.2
X846 a_n2418_2456# a_n2471_2585# a_n2516_2456# w_n6894_n2773# sky130_fd_pr__pfet_01v8 ad=0.1421 pd=1.56 as=0.1421 ps=1.56 w=0.49 l=0.2
X847 a_n5810_452# a_n5863_581# a_n5908_452# w_n6894_n2773# sky130_fd_pr__pfet_01v8 ad=0.1421 pd=1.56 as=0.1421 ps=1.56 w=0.49 l=0.2
X848 a_4366_118# a_4313_21# a_4268_118# w_n6894_n2773# sky130_fd_pr__pfet_01v8 ad=0.1421 pd=1.56 as=0.1421 ps=1.56 w=0.49 l=0.2
X849 a_n3266_1120# a_n3319_1249# a_n3364_1120# w_n6894_n2773# sky130_fd_pr__pfet_01v8 ad=0.1421 pd=1.56 as=0.1421 ps=1.56 w=0.49 l=0.2
X850 a_n2206_118# a_n2259_247# a_n2304_118# w_n6894_n2773# sky130_fd_pr__pfet_01v8 ad=0.1421 pd=1.56 as=0.1421 ps=1.56 w=0.49 l=0.2
X851 a_6274_n2554# a_6221_n2425# a_6176_n2554# w_n6894_n2773# sky130_fd_pr__pfet_01v8 ad=0.1421 pd=1.56 as=0.1421 ps=1.56 w=0.49 l=0.2
X852 a_762_2456# a_709_2359# a_664_2456# w_n6894_n2773# sky130_fd_pr__pfet_01v8 ad=0.1421 pd=1.56 as=0.1421 ps=1.56 w=0.49 l=0.2
X853 a_n5386_1788# a_n5439_1917# a_n5484_1788# w_n6894_n2773# sky130_fd_pr__pfet_01v8 ad=0.1421 pd=1.56 as=0.1421 ps=1.56 w=0.49 l=0.2
X854 a_n1358_1788# a_n1411_1691# a_n1456_1788# w_n6894_n2773# sky130_fd_pr__pfet_01v8 ad=0.1421 pd=1.56 as=0.1421 ps=1.56 w=0.49 l=0.2
X855 a_n2418_n884# a_n2471_n755# a_n2516_n884# w_n6894_n2773# sky130_fd_pr__pfet_01v8 ad=0.1421 pd=1.56 as=0.1421 ps=1.56 w=0.49 l=0.2
X856 a_n5174_786# a_n5227_915# a_n5272_786# w_n6894_n2773# sky130_fd_pr__pfet_01v8 ad=0.1421 pd=1.56 as=0.1421 ps=1.56 w=0.49 l=0.2
X857 a_n2630_118# a_n2683_247# a_n2728_118# w_n6894_n2773# sky130_fd_pr__pfet_01v8 ad=0.1421 pd=1.56 as=0.1421 ps=1.56 w=0.49 l=0.2
X858 a_n510_2456# a_n563_2359# a_n608_2456# w_n6894_n2773# sky130_fd_pr__pfet_01v8 ad=0.1421 pd=1.56 as=0.1421 ps=1.56 w=0.49 l=0.2
X859 a_4154_2122# a_4101_2251# a_4056_2122# w_n6894_n2773# sky130_fd_pr__pfet_01v8 ad=0.1421 pd=1.56 as=0.1421 ps=1.56 w=0.49 l=0.2
X860 a_762_n884# a_709_n981# a_664_n884# w_n6894_n2773# sky130_fd_pr__pfet_01v8 ad=0.1421 pd=1.56 as=0.1421 ps=1.56 w=0.49 l=0.2
X861 a_n5598_786# a_n5651_915# a_n5696_786# w_n6894_n2773# sky130_fd_pr__pfet_01v8 ad=0.1421 pd=1.56 as=0.1421 ps=1.56 w=0.49 l=0.2
X862 a_6274_452# a_6221_355# a_6176_452# w_n6894_n2773# sky130_fd_pr__pfet_01v8 ad=0.1421 pd=1.56 as=0.1421 ps=1.56 w=0.49 l=0.2
X863 a_n1570_n1886# a_n1623_n1983# a_n1668_n1886# w_n6894_n2773# sky130_fd_pr__pfet_01v8 ad=0.1421 pd=1.56 as=0.1421 ps=1.56 w=0.49 l=0.2
X864 a_n6446_n1218# a_n6499_n1089# a_n6544_n1218# w_n6894_n2773# sky130_fd_pr__pfet_01v8 ad=0.1421 pd=1.56 as=0.1421 ps=1.56 w=0.49 l=0.2
X865 a_3094_1454# a_3041_1357# a_2996_1454# w_n6894_n2773# sky130_fd_pr__pfet_01v8 ad=0.1421 pd=1.56 as=0.1421 ps=1.56 w=0.49 l=0.2
X866 a_n4114_452# a_n4167_581# a_n4212_452# w_n6894_n2773# sky130_fd_pr__pfet_01v8 ad=0.1421 pd=1.56 as=0.1421 ps=1.56 w=0.49 l=0.2
X867 a_5214_n1886# a_5161_n1983# a_5116_n1886# w_n6894_n2773# sky130_fd_pr__pfet_01v8 ad=0.1421 pd=1.56 as=0.1421 ps=1.56 w=0.49 l=0.2
X868 a_n510_n884# a_n563_n981# a_n608_n884# w_n6894_n2773# sky130_fd_pr__pfet_01v8 ad=0.1421 pd=1.56 as=0.1421 ps=1.56 w=0.49 l=0.2
X869 a_n3902_2122# a_n3955_2251# a_n4000_2122# w_n6894_n2773# sky130_fd_pr__pfet_01v8 ad=0.1421 pd=1.56 as=0.1421 ps=1.56 w=0.49 l=0.2
X870 a_6698_452# a_6645_355# a_6600_452# w_n6894_n2773# sky130_fd_pr__pfet_01v8 ad=0.1421 pd=1.56 as=0.1421 ps=1.56 w=0.49 l=0.2
X871 a_3094_118# a_3041_21# a_2996_118# w_n6894_n2773# sky130_fd_pr__pfet_01v8 ad=0.1421 pd=1.56 as=0.1421 ps=1.56 w=0.49 l=0.2
X872 a_n1358_n2220# a_n1411_n2317# a_n1456_n2220# w_n6894_n2773# sky130_fd_pr__pfet_01v8 ad=0.1421 pd=1.56 as=0.1421 ps=1.56 w=0.49 l=0.2
X873 a_n4538_452# a_n4591_581# a_n4636_452# w_n6894_n2773# sky130_fd_pr__pfet_01v8 ad=0.1421 pd=1.56 as=0.1421 ps=1.56 w=0.49 l=0.2
X874 a_n2630_n1552# a_n2683_n1649# a_n2728_n1552# w_n6894_n2773# sky130_fd_pr__pfet_01v8 ad=0.1421 pd=1.56 as=0.1421 ps=1.56 w=0.49 l=0.2
X875 a_6062_786# a_6009_689# a_5964_786# w_n6894_n2773# sky130_fd_pr__pfet_01v8 ad=0.1421 pd=1.56 as=0.1421 ps=1.56 w=0.49 l=0.2
X876 a_5426_n216# a_5373_n313# a_5328_n216# w_n6894_n2773# sky130_fd_pr__pfet_01v8 ad=0.1421 pd=1.56 as=0.1421 ps=1.56 w=0.49 l=0.2
X877 a_2034_n2554# a_1981_n2425# a_1936_n2554# w_n6894_n2773# sky130_fd_pr__pfet_01v8 ad=0.1421 pd=1.56 as=0.1421 ps=1.56 w=0.49 l=0.2
X878 a_n2842_1454# a_n2895_1357# a_n2940_1454# w_n6894_n2773# sky130_fd_pr__pfet_01v8 ad=0.1421 pd=1.56 as=0.1421 ps=1.56 w=0.49 l=0.2
X879 a_3518_118# a_3465_21# a_3420_118# w_n6894_n2773# sky130_fd_pr__pfet_01v8 ad=0.1421 pd=1.56 as=0.1421 ps=1.56 w=0.49 l=0.2
X880 a_n1358_118# a_n1411_247# a_n1456_118# w_n6894_n2773# sky130_fd_pr__pfet_01v8 ad=0.1421 pd=1.56 as=0.1421 ps=1.56 w=0.49 l=0.2
X881 a_3730_2456# a_3677_2359# a_3632_2456# w_n6894_n2773# sky130_fd_pr__pfet_01v8 ad=0.1421 pd=1.56 as=0.1421 ps=1.56 w=0.49 l=0.2
X882 a_n4326_786# a_n4379_915# a_n4424_786# w_n6894_n2773# sky130_fd_pr__pfet_01v8 ad=0.1421 pd=1.56 as=0.1421 ps=1.56 w=0.49 l=0.2
X883 a_6486_786# a_6433_689# a_6388_786# w_n6894_n2773# sky130_fd_pr__pfet_01v8 ad=0.1421 pd=1.56 as=0.1421 ps=1.56 w=0.49 l=0.2
X884 a_6062_n2554# a_6009_n2651# a_5964_n2554# w_n6894_n2773# sky130_fd_pr__pfet_01v8 ad=0.1421 pd=1.56 as=0.1421 ps=1.56 w=0.49 l=0.2
X885 a_n3266_1788# a_n3319_1917# a_n3364_1788# w_n6894_n2773# sky130_fd_pr__pfet_01v8 ad=0.1421 pd=1.56 as=0.1421 ps=1.56 w=0.49 l=0.2
X886 a_n5810_2122# a_n5863_2025# a_n5908_2122# w_n6894_n2773# sky130_fd_pr__pfet_01v8 ad=0.1421 pd=1.56 as=0.1421 ps=1.56 w=0.49 l=0.2
X887 a_n934_1454# a_n987_1583# a_n1032_1454# w_n6894_n2773# sky130_fd_pr__pfet_01v8 ad=0.1421 pd=1.56 as=0.1421 ps=1.56 w=0.49 l=0.2
X888 a_5850_n1886# a_5797_n1757# a_5752_n1886# w_n6894_n2773# sky130_fd_pr__pfet_01v8 ad=0.1421 pd=1.56 as=0.1421 ps=1.56 w=0.49 l=0.2
X889 a_3730_n884# a_3677_n981# a_3632_n884# w_n6894_n2773# sky130_fd_pr__pfet_01v8 ad=0.1421 pd=1.56 as=0.1421 ps=1.56 w=0.49 l=0.2
X890 a_n4750_786# a_n4803_915# a_n4848_786# w_n6894_n2773# sky130_fd_pr__pfet_01v8 ad=0.1421 pd=1.56 as=0.1421 ps=1.56 w=0.49 l=0.2
X891 a_550_452# a_497_581# a_452_452# w_n6894_n2773# sky130_fd_pr__pfet_01v8 ad=0.1421 pd=1.56 as=0.1421 ps=1.56 w=0.49 l=0.2
X892 a_5426_452# a_5373_355# a_5328_452# w_n6894_n2773# sky130_fd_pr__pfet_01v8 ad=0.1421 pd=1.56 as=0.1421 ps=1.56 w=0.49 l=0.2
X893 a_n6234_2122# a_n6287_2025# a_n6332_2122# w_n6894_n2773# sky130_fd_pr__pfet_01v8 ad=0.1421 pd=1.56 as=0.1421 ps=1.56 w=0.49 l=0.2
X894 a_n5598_n550# a_n5651_n421# a_n5696_n550# w_n6894_n2773# sky130_fd_pr__pfet_01v8 ad=0.1421 pd=1.56 as=0.1421 ps=1.56 w=0.49 l=0.2
X895 a_n6234_n1218# a_n6287_n1315# a_n6332_n1218# w_n6894_n2773# sky130_fd_pr__pfet_01v8 ad=0.1421 pd=1.56 as=0.1421 ps=1.56 w=0.49 l=0.2
X896 a_n4750_1454# a_n4803_1583# a_n4848_1454# w_n6894_n2773# sky130_fd_pr__pfet_01v8 ad=0.1421 pd=1.56 as=0.1421 ps=1.56 w=0.49 l=0.2
X897 a_126_2122# a_73_2025# a_28_2122# w_n6894_n2773# sky130_fd_pr__pfet_01v8 ad=0.1421 pd=1.56 as=0.1421 ps=1.56 w=0.49 l=0.2
X898 a_974_452# a_921_581# a_876_452# w_n6894_n2773# sky130_fd_pr__pfet_01v8 ad=0.1421 pd=1.56 as=0.1421 ps=1.56 w=0.49 l=0.2
X899 a_n6022_n550# a_n6075_n421# a_n6120_n550# w_n6894_n2773# sky130_fd_pr__pfet_01v8 ad=0.1421 pd=1.56 as=0.1421 ps=1.56 w=0.49 l=0.2
X900 a_5638_2456# a_5585_2585# a_5540_2456# w_n6894_n2773# sky130_fd_pr__pfet_01v8 ad=0.1421 pd=1.56 as=0.1421 ps=1.56 w=0.49 l=0.2
X901 a_n1782_2122# a_n1835_2251# a_n1880_2122# w_n6894_n2773# sky130_fd_pr__pfet_01v8 ad=0.1421 pd=1.56 as=0.1421 ps=1.56 w=0.49 l=0.2
X902 a_n4750_n2554# a_n4803_n2425# a_n4848_n2554# w_n6894_n2773# sky130_fd_pr__pfet_01v8 ad=0.1421 pd=1.56 as=0.1421 ps=1.56 w=0.49 l=0.2
X903 a_n1146_n2220# a_n1199_n2091# a_n1244_n2220# w_n6894_n2773# sky130_fd_pr__pfet_01v8 ad=0.1421 pd=1.56 as=0.1421 ps=1.56 w=0.49 l=0.2
X904 a_5214_786# a_5161_689# a_5116_786# w_n6894_n2773# sky130_fd_pr__pfet_01v8 ad=0.1421 pd=1.56 as=0.1421 ps=1.56 w=0.49 l=0.2
X905 a_n2418_n1552# a_n2471_n1423# a_n2516_n1552# w_n6894_n2773# sky130_fd_pr__pfet_01v8 ad=0.1421 pd=1.56 as=0.1421 ps=1.56 w=0.49 l=0.2
X906 a_6486_1120# a_6433_1249# a_6388_1120# w_n6894_n2773# sky130_fd_pr__pfet_01v8 ad=0.1421 pd=1.56 as=0.1421 ps=1.56 w=0.49 l=0.2
X907 a_n3054_786# a_n3107_915# a_n3152_786# w_n6894_n2773# sky130_fd_pr__pfet_01v8 ad=0.1421 pd=1.56 as=0.1421 ps=1.56 w=0.49 l=0.2
X908 a_3306_n216# a_3253_n313# a_3208_n216# w_n6894_n2773# sky130_fd_pr__pfet_01v8 ad=0.1421 pd=1.56 as=0.1421 ps=1.56 w=0.49 l=0.2
X909 a_1822_n2554# a_1769_n2651# a_1724_n2554# w_n6894_n2773# sky130_fd_pr__pfet_01v8 ad=0.1421 pd=1.56 as=0.1421 ps=1.56 w=0.49 l=0.2
X910 a_5638_n884# a_5585_n755# a_5540_n884# w_n6894_n2773# sky130_fd_pr__pfet_01v8 ad=0.1421 pd=1.56 as=0.1421 ps=1.56 w=0.49 l=0.2
X911 a_5638_786# a_5585_689# a_5540_786# w_n6894_n2773# sky130_fd_pr__pfet_01v8 ad=0.1421 pd=1.56 as=0.1421 ps=1.56 w=0.49 l=0.2
X912 a_762_786# a_709_915# a_664_786# w_n6894_n2773# sky130_fd_pr__pfet_01v8 ad=0.1421 pd=1.56 as=0.1421 ps=1.56 w=0.49 l=0.2
X913 a_1610_2456# a_1557_2359# a_1512_2456# w_n6894_n2773# sky130_fd_pr__pfet_01v8 ad=0.1421 pd=1.56 as=0.1421 ps=1.56 w=0.49 l=0.2
X914 a_n3690_2122# a_n3743_2025# a_n3788_2122# w_n6894_n2773# sky130_fd_pr__pfet_01v8 ad=0.1421 pd=1.56 as=0.1421 ps=1.56 w=0.49 l=0.2
X915 a_1610_n884# a_1557_n981# a_1512_n884# w_n6894_n2773# sky130_fd_pr__pfet_01v8 ad=0.1421 pd=1.56 as=0.1421 ps=1.56 w=0.49 l=0.2
X916 a_3942_452# a_3889_581# a_3844_452# w_n6894_n2773# sky130_fd_pr__pfet_01v8 ad=0.1421 pd=1.56 as=0.1421 ps=1.56 w=0.49 l=0.2
X917 a_n4114_2122# a_n4167_2025# a_n4212_2122# w_n6894_n2773# sky130_fd_pr__pfet_01v8 ad=0.1421 pd=1.56 as=0.1421 ps=1.56 w=0.49 l=0.2
X918 a_n1782_452# a_n1835_355# a_n1880_452# w_n6894_n2773# sky130_fd_pr__pfet_01v8 ad=0.1421 pd=1.56 as=0.1421 ps=1.56 w=0.49 l=0.2
X919 a_n3478_n550# a_n3531_n421# a_n3576_n550# w_n6894_n2773# sky130_fd_pr__pfet_01v8 ad=0.1421 pd=1.56 as=0.1421 ps=1.56 w=0.49 l=0.2
X920 a_n1782_n2220# a_n1835_n2317# a_n1880_n2220# w_n6894_n2773# sky130_fd_pr__pfet_01v8 ad=0.1421 pd=1.56 as=0.1421 ps=1.56 w=0.49 l=0.2
X921 a_n6022_n1218# a_n6075_n1089# a_n6120_n1218# w_n6894_n2773# sky130_fd_pr__pfet_01v8 ad=0.1421 pd=1.56 as=0.1421 ps=1.56 w=0.49 l=0.2
X922 a_n2630_1454# a_n2683_1583# a_n2728_1454# w_n6894_n2773# sky130_fd_pr__pfet_01v8 ad=0.1421 pd=1.56 as=0.1421 ps=1.56 w=0.49 l=0.2
X923 a_n510_n1886# a_n563_n1757# a_n608_n1886# w_n6894_n2773# sky130_fd_pr__pfet_01v8 ad=0.1421 pd=1.56 as=0.1421 ps=1.56 w=0.49 l=0.2
X924 a_3518_2456# a_3465_2585# a_3420_2456# w_n6894_n2773# sky130_fd_pr__pfet_01v8 ad=0.1421 pd=1.56 as=0.1421 ps=1.56 w=0.49 l=0.2
X925 a_n3054_1454# a_n3107_1583# a_n3152_1454# w_n6894_n2773# sky130_fd_pr__pfet_01v8 ad=0.1421 pd=1.56 as=0.1421 ps=1.56 w=0.49 l=0.2
X926 a_974_1454# a_921_1357# a_876_1454# w_n6894_n2773# sky130_fd_pr__pfet_01v8 ad=0.1421 pd=1.56 as=0.1421 ps=1.56 w=0.49 l=0.2
X927 a_n4538_n2554# a_n4591_n2651# a_n4636_n2554# w_n6894_n2773# sky130_fd_pr__pfet_01v8 ad=0.1421 pd=1.56 as=0.1421 ps=1.56 w=0.49 l=0.2
X928 a_n2206_n1552# a_n2259_n1649# a_n2304_n1552# w_n6894_n2773# sky130_fd_pr__pfet_01v8 ad=0.1421 pd=1.56 as=0.1421 ps=1.56 w=0.49 l=0.2
X929 a_6486_1788# a_6433_1917# a_6388_1788# w_n6894_n2773# sky130_fd_pr__pfet_01v8 ad=0.1421 pd=1.56 as=0.1421 ps=1.56 w=0.49 l=0.2
X930 a_4366_1120# a_4313_1249# a_4268_1120# w_n6894_n2773# sky130_fd_pr__pfet_01v8 ad=0.1421 pd=1.56 as=0.1421 ps=1.56 w=0.49 l=0.2
X931 a_1186_n216# a_1133_n313# a_1088_n216# w_n6894_n2773# sky130_fd_pr__pfet_01v8 ad=0.1421 pd=1.56 as=0.1421 ps=1.56 w=0.49 l=0.2
X932 a_1610_n2554# a_1557_n2425# a_1512_n2554# w_n6894_n2773# sky130_fd_pr__pfet_01v8 ad=0.1421 pd=1.56 as=0.1421 ps=1.56 w=0.49 l=0.2
X933 a_n3690_n1218# a_n3743_n1315# a_n3788_n1218# w_n6894_n2773# sky130_fd_pr__pfet_01v8 ad=0.1421 pd=1.56 as=0.1421 ps=1.56 w=0.49 l=0.2
X934 a_3518_n884# a_3465_n755# a_3420_n884# w_n6894_n2773# sky130_fd_pr__pfet_01v8 ad=0.1421 pd=1.56 as=0.1421 ps=1.56 w=0.49 l=0.2
X935 a_2458_n1886# a_2405_n1757# a_2360_n1886# w_n6894_n2773# sky130_fd_pr__pfet_01v8 ad=0.1421 pd=1.56 as=0.1421 ps=1.56 w=0.49 l=0.2
X936 a_2670_452# a_2617_581# a_2572_452# w_n6894_n2773# sky130_fd_pr__pfet_01v8 ad=0.1421 pd=1.56 as=0.1421 ps=1.56 w=0.49 l=0.2
X937 a_3518_n1552# a_3465_n1423# a_3420_n1552# w_n6894_n2773# sky130_fd_pr__pfet_01v8 ad=0.1421 pd=1.56 as=0.1421 ps=1.56 w=0.49 l=0.2
X938 a_n1570_2122# a_n1623_2025# a_n1668_2122# w_n6894_n2773# sky130_fd_pr__pfet_01v8 ad=0.1421 pd=1.56 as=0.1421 ps=1.56 w=0.49 l=0.2
X939 a_338_2122# a_285_2251# a_240_2122# w_n6894_n2773# sky130_fd_pr__pfet_01v8 ad=0.1421 pd=1.56 as=0.1421 ps=1.56 w=0.49 l=0.2
X940 a_5002_2122# a_4949_2251# a_4904_2122# w_n6894_n2773# sky130_fd_pr__pfet_01v8 ad=0.1421 pd=1.56 as=0.1421 ps=1.56 w=0.49 l=0.2
X941 a_n1994_2122# a_n2047_2025# a_n2092_2122# w_n6894_n2773# sky130_fd_pr__pfet_01v8 ad=0.1421 pd=1.56 as=0.1421 ps=1.56 w=0.49 l=0.2
X942 a_4790_n550# a_4737_n647# a_4692_n550# w_n6894_n2773# sky130_fd_pr__pfet_01v8 ad=0.1421 pd=1.56 as=0.1421 ps=1.56 w=0.49 l=0.2
X943 a_n934_n2220# a_n987_n2317# a_n1032_n2220# w_n6894_n2773# sky130_fd_pr__pfet_01v8 ad=0.1421 pd=1.56 as=0.1421 ps=1.56 w=0.49 l=0.2
X944 a_n298_n1886# a_n351_n1983# a_n396_n1886# w_n6894_n2773# sky130_fd_pr__pfet_01v8 ad=0.1421 pd=1.56 as=0.1421 ps=1.56 w=0.49 l=0.2
X945 a_1398_2456# a_1345_2585# a_1300_2456# w_n6894_n2773# sky130_fd_pr__pfet_01v8 ad=0.1421 pd=1.56 as=0.1421 ps=1.56 w=0.49 l=0.2
X946 a_n4962_1454# a_n5015_1357# a_n5060_1454# w_n6894_n2773# sky130_fd_pr__pfet_01v8 ad=0.1421 pd=1.56 as=0.1421 ps=1.56 w=0.49 l=0.2
X947 a_2882_786# a_2829_915# a_2784_786# w_n6894_n2773# sky130_fd_pr__pfet_01v8 ad=0.1421 pd=1.56 as=0.1421 ps=1.56 w=0.49 l=0.2
X948 a_n4326_n2554# a_n4379_n2425# a_n4424_n2554# w_n6894_n2773# sky130_fd_pr__pfet_01v8 ad=0.1421 pd=1.56 as=0.1421 ps=1.56 w=0.49 l=0.2
X949 a_n86_2122# a_n139_2251# a_n184_2122# w_n6894_n2773# sky130_fd_pr__pfet_01v8 ad=0.1421 pd=1.56 as=0.1421 ps=1.56 w=0.49 l=0.2
X950 a_n5810_n2220# a_n5863_n2091# a_n5908_n2220# w_n6894_n2773# sky130_fd_pr__pfet_01v8 ad=0.1421 pd=1.56 as=0.1421 ps=1.56 w=0.49 l=0.2
X951 a_n1994_n1552# a_n2047_n1423# a_n2092_n1552# w_n6894_n2773# sky130_fd_pr__pfet_01v8 ad=0.1421 pd=1.56 as=0.1421 ps=1.56 w=0.49 l=0.2
X952 a_4366_1788# a_4313_1917# a_4268_1788# w_n6894_n2773# sky130_fd_pr__pfet_01v8 ad=0.1421 pd=1.56 as=0.1421 ps=1.56 w=0.49 l=0.2
X953 a_2246_1120# a_2193_1249# a_2148_1120# w_n6894_n2773# sky130_fd_pr__pfet_01v8 ad=0.1421 pd=1.56 as=0.1421 ps=1.56 w=0.49 l=0.2
X954 a_2246_n1886# a_2193_n1983# a_2148_n1886# w_n6894_n2773# sky130_fd_pr__pfet_01v8 ad=0.1421 pd=1.56 as=0.1421 ps=1.56 w=0.49 l=0.2
X955 a_n3478_n1218# a_n3531_n1089# a_n3576_n1218# w_n6894_n2773# sky130_fd_pr__pfet_01v8 ad=0.1421 pd=1.56 as=0.1421 ps=1.56 w=0.49 l=0.2
X956 a_1398_n884# a_1345_n755# a_1300_n884# w_n6894_n2773# sky130_fd_pr__pfet_01v8 ad=0.1421 pd=1.56 as=0.1421 ps=1.56 w=0.49 l=0.2
X957 a_n934_118# a_n987_247# a_n1032_118# w_n6894_n2773# sky130_fd_pr__pfet_01v8 ad=0.1421 pd=1.56 as=0.1421 ps=1.56 w=0.49 l=0.2
X958 a_2882_n2220# a_2829_n2317# a_2784_n2220# w_n6894_n2773# sky130_fd_pr__pfet_01v8 ad=0.1421 pd=1.56 as=0.1421 ps=1.56 w=0.49 l=0.2
X959 a_n6446_1120# a_n6499_1023# a_n6544_1120# w_n6894_n2773# sky130_fd_pr__pfet_01v8 ad=0.1421 pd=1.56 as=0.1421 ps=1.56 w=0.49 l=0.2
X960 a_1822_452# a_1769_581# a_1724_452# w_n6894_n2773# sky130_fd_pr__pfet_01v8 ad=0.1421 pd=1.56 as=0.1421 ps=1.56 w=0.49 l=0.2
X961 a_6698_n550# a_6645_n421# a_6600_n550# w_n6894_n2773# sky130_fd_pr__pfet_01v8 ad=0.1421 pd=1.56 as=0.1421 ps=1.56 w=0.49 l=0.2
X962 a_5638_n2554# a_5585_n2651# a_5540_n2554# w_n6894_n2773# sky130_fd_pr__pfet_01v8 ad=0.1421 pd=1.56 as=0.1421 ps=1.56 w=0.49 l=0.2
X963 a_3306_n1552# a_3253_n1649# a_3208_n1552# w_n6894_n2773# sky130_fd_pr__pfet_01v8 ad=0.1421 pd=1.56 as=0.1421 ps=1.56 w=0.49 l=0.2
X964 a_2882_2122# a_2829_2251# a_2784_2122# w_n6894_n2773# sky130_fd_pr__pfet_01v8 ad=0.1421 pd=1.56 as=0.1421 ps=1.56 w=0.49 l=0.2
X965 a_1610_786# a_1557_915# a_1512_786# w_n6894_n2773# sky130_fd_pr__pfet_01v8 ad=0.1421 pd=1.56 as=0.1421 ps=1.56 w=0.49 l=0.2
X966 a_n1570_786# a_n1623_689# a_n1668_786# w_n6894_n2773# sky130_fd_pr__pfet_01v8 ad=0.1421 pd=1.56 as=0.1421 ps=1.56 w=0.49 l=0.2
X967 a_2246_452# a_2193_581# a_2148_452# w_n6894_n2773# sky130_fd_pr__pfet_01v8 ad=0.1421 pd=1.56 as=0.1421 ps=1.56 w=0.49 l=0.2
X968 a_2670_n550# a_2617_n647# a_2572_n550# w_n6894_n2773# sky130_fd_pr__pfet_01v8 ad=0.1421 pd=1.56 as=0.1421 ps=1.56 w=0.49 l=0.2
X969 a_338_n1218# a_285_n1089# a_240_n1218# w_n6894_n2773# sky130_fd_pr__pfet_01v8 ad=0.1421 pd=1.56 as=0.1421 ps=1.56 w=0.49 l=0.2
X970 a_1822_1454# a_1769_1357# a_1724_1454# w_n6894_n2773# sky130_fd_pr__pfet_01v8 ad=0.1421 pd=1.56 as=0.1421 ps=1.56 w=0.49 l=0.2
X971 a_5850_1454# a_5797_1583# a_5752_1454# w_n6894_n2773# sky130_fd_pr__pfet_01v8 ad=0.1421 pd=1.56 as=0.1421 ps=1.56 w=0.49 l=0.2
X972 a_2034_786# a_1981_915# a_1936_786# w_n6894_n2773# sky130_fd_pr__pfet_01v8 ad=0.1421 pd=1.56 as=0.1421 ps=1.56 w=0.49 l=0.2
X973 a_n722_n2220# a_n775_n2091# a_n820_n2220# w_n6894_n2773# sky130_fd_pr__pfet_01v8 ad=0.1421 pd=1.56 as=0.1421 ps=1.56 w=0.49 l=0.2
X974 a_n86_n1886# a_n139_n1757# a_n184_n1886# w_n6894_n2773# sky130_fd_pr__pfet_01v8 ad=0.1421 pd=1.56 as=0.1421 ps=1.56 w=0.49 l=0.2
X975 a_n4114_n2554# a_n4167_n2651# a_n4212_n2554# w_n6894_n2773# sky130_fd_pr__pfet_01v8 ad=0.1421 pd=1.56 as=0.1421 ps=1.56 w=0.49 l=0.2
X976 a_n5598_n2220# a_n5651_n2317# a_n5696_n2220# w_n6894_n2773# sky130_fd_pr__pfet_01v8 ad=0.1421 pd=1.56 as=0.1421 ps=1.56 w=0.49 l=0.2
X977 a_2246_1788# a_2193_1917# a_2148_1788# w_n6894_n2773# sky130_fd_pr__pfet_01v8 ad=0.1421 pd=1.56 as=0.1421 ps=1.56 w=0.49 l=0.2
X978 a_n3902_n1886# a_n3955_n1757# a_n4000_n1886# w_n6894_n2773# sky130_fd_pr__pfet_01v8 ad=0.1421 pd=1.56 as=0.1421 ps=1.56 w=0.49 l=0.2
X979 a_n3266_n1218# a_n3319_n1315# a_n3364_n1218# w_n6894_n2773# sky130_fd_pr__pfet_01v8 ad=0.1421 pd=1.56 as=0.1421 ps=1.56 w=0.49 l=0.2
X980 a_n5174_n216# a_n5227_n313# a_n5272_n216# w_n6894_n2773# sky130_fd_pr__pfet_01v8 ad=0.1421 pd=1.56 as=0.1421 ps=1.56 w=0.49 l=0.2
X981 a_n1146_n216# a_n1199_n87# a_n1244_n216# w_n6894_n2773# sky130_fd_pr__pfet_01v8 ad=0.1421 pd=1.56 as=0.1421 ps=1.56 w=0.49 l=0.2
X982 a_2670_n2220# a_2617_n2091# a_2572_n2220# w_n6894_n2773# sky130_fd_pr__pfet_01v8 ad=0.1421 pd=1.56 as=0.1421 ps=1.56 w=0.49 l=0.2
X983 a_n6446_1788# a_n6499_1691# a_n6544_1788# w_n6894_n2773# sky130_fd_pr__pfet_01v8 ad=0.1421 pd=1.56 as=0.1421 ps=1.56 w=0.49 l=0.2
X984 a_n4326_1120# a_n4379_1023# a_n4424_1120# w_n6894_n2773# sky130_fd_pr__pfet_01v8 ad=0.1421 pd=1.56 as=0.1421 ps=1.56 w=0.49 l=0.2
X985 a_3942_n1552# a_3889_n1423# a_3844_n1552# w_n6894_n2773# sky130_fd_pr__pfet_01v8 ad=0.1421 pd=1.56 as=0.1421 ps=1.56 w=0.49 l=0.2
X986 a_4578_n550# a_4525_n421# a_4480_n550# w_n6894_n2773# sky130_fd_pr__pfet_01v8 ad=0.1421 pd=1.56 as=0.1421 ps=1.56 w=0.49 l=0.2
X987 a_5426_n2554# a_5373_n2425# a_5328_n2554# w_n6894_n2773# sky130_fd_pr__pfet_01v8 ad=0.1421 pd=1.56 as=0.1421 ps=1.56 w=0.49 l=0.2
X988 a_n3054_n1886# a_n3107_n1757# a_n3152_n1886# w_n6894_n2773# sky130_fd_pr__pfet_01v8 ad=0.1421 pd=1.56 as=0.1421 ps=1.56 w=0.49 l=0.2
X989 a_5214_2122# a_5161_2025# a_5116_2122# w_n6894_n2773# sky130_fd_pr__pfet_01v8 ad=0.1421 pd=1.56 as=0.1421 ps=1.56 w=0.49 l=0.2
X990 a_2458_786# a_2405_915# a_2360_786# w_n6894_n2773# sky130_fd_pr__pfet_01v8 ad=0.1421 pd=1.56 as=0.1421 ps=1.56 w=0.49 l=0.2
X991 a_n86_118# a_n139_247# a_n184_118# w_n6894_n2773# sky130_fd_pr__pfet_01v8 ad=0.1421 pd=1.56 as=0.1421 ps=1.56 w=0.49 l=0.2
X992 a_3094_n1552# a_3041_n1423# a_2996_n1552# w_n6894_n2773# sky130_fd_pr__pfet_01v8 ad=0.1421 pd=1.56 as=0.1421 ps=1.56 w=0.49 l=0.2
X993 a_4578_n1218# a_4525_n1089# a_4480_n1218# w_n6894_n2773# sky130_fd_pr__pfet_01v8 ad=0.1421 pd=1.56 as=0.1421 ps=1.56 w=0.49 l=0.2
X994 a_974_n1218# a_921_n1315# a_876_n1218# w_n6894_n2773# sky130_fd_pr__pfet_01v8 ad=0.1421 pd=1.56 as=0.1421 ps=1.56 w=0.49 l=0.2
X995 a_n510_118# a_n563_247# a_n608_118# w_n6894_n2773# sky130_fd_pr__pfet_01v8 ad=0.1421 pd=1.56 as=0.1421 ps=1.56 w=0.49 l=0.2
X996 a_1398_452# a_1345_581# a_1300_452# w_n6894_n2773# sky130_fd_pr__pfet_01v8 ad=0.1421 pd=1.56 as=0.1421 ps=1.56 w=0.49 l=0.2
X997 a_n5386_2456# a_n5439_2585# a_n5484_2456# w_n6894_n2773# sky130_fd_pr__pfet_01v8 ad=0.1421 pd=1.56 as=0.1421 ps=1.56 w=0.49 l=0.2
X998 a_n5386_n2220# a_n5439_n2091# a_n5484_n2220# w_n6894_n2773# sky130_fd_pr__pfet_01v8 ad=0.1421 pd=1.56 as=0.1421 ps=1.56 w=0.49 l=0.2
X999 a_n1358_2456# a_n1411_2359# a_n1456_2456# w_n6894_n2773# sky130_fd_pr__pfet_01v8 ad=0.1421 pd=1.56 as=0.1421 ps=1.56 w=0.49 l=0.2
X1000 a_1186_786# a_1133_915# a_1088_786# w_n6894_n2773# sky130_fd_pr__pfet_01v8 ad=0.1421 pd=1.56 as=0.1421 ps=1.56 w=0.49 l=0.2
X1001 a_2034_n216# a_1981_n313# a_1936_n216# w_n6894_n2773# sky130_fd_pr__pfet_01v8 ad=0.1421 pd=1.56 as=0.1421 ps=1.56 w=0.49 l=0.2
X1002 a_126_n2220# a_73_n2091# a_28_n2220# w_n6894_n2773# sky130_fd_pr__pfet_01v8 ad=0.1421 pd=1.56 as=0.1421 ps=1.56 w=0.49 l=0.2
X1003 a_n4326_1788# a_n4379_1691# a_n4424_1788# w_n6894_n2773# sky130_fd_pr__pfet_01v8 ad=0.1421 pd=1.56 as=0.1421 ps=1.56 w=0.49 l=0.2
X1004 a_n2206_1120# a_n2259_1023# a_n2304_1120# w_n6894_n2773# sky130_fd_pr__pfet_01v8 ad=0.1421 pd=1.56 as=0.1421 ps=1.56 w=0.49 l=0.2
X1005 a_n1570_n2554# a_n1623_n2651# a_n1668_n2554# w_n6894_n2773# sky130_fd_pr__pfet_01v8 ad=0.1421 pd=1.56 as=0.1421 ps=1.56 w=0.49 l=0.2
X1006 a_n1358_n884# a_n1411_n981# a_n1456_n884# w_n6894_n2773# sky130_fd_pr__pfet_01v8 ad=0.1421 pd=1.56 as=0.1421 ps=1.56 w=0.49 l=0.2
X1007 a_n5386_n884# a_n5439_n755# a_n5484_n884# w_n6894_n2773# sky130_fd_pr__pfet_01v8 ad=0.1421 pd=1.56 as=0.1421 ps=1.56 w=0.49 l=0.2
X1008 a_2458_n550# a_2405_n421# a_2360_n550# w_n6894_n2773# sky130_fd_pr__pfet_01v8 ad=0.1421 pd=1.56 as=0.1421 ps=1.56 w=0.49 l=0.2
X1009 a_5214_n2554# a_5161_n2651# a_5116_n2554# w_n6894_n2773# sky130_fd_pr__pfet_01v8 ad=0.1421 pd=1.56 as=0.1421 ps=1.56 w=0.49 l=0.2
X1010 a_3094_2122# a_3041_2025# a_2996_2122# w_n6894_n2773# sky130_fd_pr__pfet_01v8 ad=0.1421 pd=1.56 as=0.1421 ps=1.56 w=0.49 l=0.2
X1011 a_550_1120# a_497_1249# a_452_1120# w_n6894_n2773# sky130_fd_pr__pfet_01v8 ad=0.1421 pd=1.56 as=0.1421 ps=1.56 w=0.49 l=0.2
X1012 a_n6658_n550# a_n6711_n647# a_n6756_n550# w_n6894_n2773# sky130_fd_pr__pfet_01v8 ad=0.1421 pd=1.56 as=0.1421 ps=1.56 w=0.49 l=0.2
X1013 a_6698_n2220# a_6645_n2317# a_6600_n2220# w_n6894_n2773# sky130_fd_pr__pfet_01v8 ad=0.1421 pd=1.56 as=0.1421 ps=1.56 w=0.49 l=0.2
X1014 a_4366_n1218# a_4313_n1315# a_4268_n1218# w_n6894_n2773# sky130_fd_pr__pfet_01v8 ad=0.1421 pd=1.56 as=0.1421 ps=1.56 w=0.49 l=0.2
X1015 a_762_n1218# a_709_n1089# a_664_n1218# w_n6894_n2773# sky130_fd_pr__pfet_01v8 ad=0.1421 pd=1.56 as=0.1421 ps=1.56 w=0.49 l=0.2
X1016 a_6062_1454# a_6009_1357# a_5964_1454# w_n6894_n2773# sky130_fd_pr__pfet_01v8 ad=0.1421 pd=1.56 as=0.1421 ps=1.56 w=0.49 l=0.2
X1017 a_n298_1120# a_n351_1249# a_n396_1120# w_n6894_n2773# sky130_fd_pr__pfet_01v8 ad=0.1421 pd=1.56 as=0.1421 ps=1.56 w=0.49 l=0.2
X1018 a_5002_n1886# a_4949_n1757# a_4904_n1886# w_n6894_n2773# sky130_fd_pr__pfet_01v8 ad=0.1421 pd=1.56 as=0.1421 ps=1.56 w=0.49 l=0.2
X1019 a_n2842_2122# a_n2895_2025# a_n2940_2122# w_n6894_n2773# sky130_fd_pr__pfet_01v8 ad=0.1421 pd=1.56 as=0.1421 ps=1.56 w=0.49 l=0.2
X1020 a_n3266_2456# a_n3319_2585# a_n3364_2456# w_n6894_n2773# sky130_fd_pr__pfet_01v8 ad=0.1421 pd=1.56 as=0.1421 ps=1.56 w=0.49 l=0.2
X1021 a_n5174_n2220# a_n5227_n2317# a_n5272_n2220# w_n6894_n2773# sky130_fd_pr__pfet_01v8 ad=0.1421 pd=1.56 as=0.1421 ps=1.56 w=0.49 l=0.2
X1022 a_n934_2122# a_n987_2251# a_n1032_2122# w_n6894_n2773# sky130_fd_pr__pfet_01v8 ad=0.1421 pd=1.56 as=0.1421 ps=1.56 w=0.49 l=0.2
X1023 a_3942_n216# a_3889_n87# a_3844_n216# w_n6894_n2773# sky130_fd_pr__pfet_01v8 ad=0.1421 pd=1.56 as=0.1421 ps=1.56 w=0.49 l=0.2
.ends

.subckt power-fet VIN B A
XXM1 VIN B B A A B VIN B B VIN B VIN VIN VIN A VIN B A B B A A VIN VIN VIN VIN VIN
+ VIN A B A B B VIN A VIN VIN A VIN A B A A VIN B VIN VIN VIN B VIN B VIN A B VIN
+ A A VIN B A A B A VIN VIN B VIN VIN B A VIN VIN VIN B B VIN VIN VIN A VIN VIN B
+ VIN VIN B A B VIN B VIN A B A VIN VIN VIN VIN VIN A B A VIN B VIN VIN VIN VIN VIN
+ B B A A B B A A A A A A A A A A B B A VIN A A A B B VIN B A A B B VIN B A B B B
+ VIN B A B VIN B VIN B VIN B B B B B VIN VIN B A A B B B A A VIN B VIN B B A A B
+ A A VIN A B VIN B B VIN B B B B A A VIN B VIN A B A VIN B B VIN VIN A VIN A A B
+ VIN A B B B A A A VIN B A A VIN VIN B B VIN VIN VIN B A B B A A A VIN A B A VIN
+ A A VIN A A A A B A B B A A A A A B A A VIN VIN VIN VIN VIN VIN VIN B A VIN VIN
+ A A A B VIN VIN A VIN A A VIN VIN VIN B VIN B VIN VIN B VIN B VIN A VIN A B B B
+ A B A B B B VIN VIN B B A B VIN A A B VIN VIN B B B B VIN B B B B B A VIN A VIN
+ VIN B VIN B B B A VIN B VIN B A A A A A A B A A VIN VIN VIN B B B VIN A B VIN VIN
+ B A A VIN B A VIN A B VIN VIN A VIN B VIN A VIN VIN VIN VIN A A VIN VIN VIN A B
+ A VIN A VIN B B A A A A A A B A VIN B A A B B VIN A A A B A B VIN VIN VIN A VIN
+ A B VIN VIN A VIN B B A VIN A VIN VIN B A B VIN VIN B VIN B VIN VIN A A B A B B
+ B VIN B VIN B A A VIN VIN A B A B A VIN B A B A B A B VIN B VIN A A B VIN VIN VIN
+ A A VIN VIN A A A B B A VIN A B A B A A A A VIN A VIN A VIN B VIN VIN B VIN VIN
+ VIN VIN VIN VIN VIN VIN A VIN B A B B VIN VIN B VIN VIN VIN VIN A A B B VIN VIN
+ A VIN B VIN B VIN A VIN A VIN A B B VIN B B B B VIN B B B VIN A A B VIN A B B B
+ B VIN VIN A VIN B B VIN B B A B B B VIN B B B A B VIN VIN B B A B VIN A A A B B
+ B B B A B B VIN VIN A VIN A VIN B B VIN A B A VIN A A B VIN VIN B B VIN A A A A
+ A B B A A B VIN A VIN A A VIN A VIN A B A A A A B B A A A VIN A A A B A A VIN A
+ A B VIN A A VIN A A A A B VIN VIN B A VIN B B A B VIN B VIN B VIN VIN B VIN A VIN
+ VIN B VIN B VIN VIN VIN B A B A B A VIN A B B A VIN VIN A VIN A B B B A VIN B A
+ VIN A B A VIN B A VIN VIN VIN B B A VIN A B A B A VIN B VIN VIN VIN A B A B A A
+ A VIN A A B VIN A B B VIN VIN A VIN A VIN A VIN VIN A VIN VIN VIN VIN VIN A VIN
+ A VIN VIN B B B VIN A A A B B VIN A VIN B VIN VIN VIN A B VIN A A B VIN VIN VIN
+ VIN VIN A VIN A VIN VIN VIN B A B B A A B B A B A A A VIN A VIN A A VIN A B VIN
+ B VIN A B B VIN VIN B B VIN VIN A VIN B B VIN B B B B B B VIN VIN VIN A VIN B B
+ A B VIN A VIN B B VIN VIN B B B VIN VIN VIN B B B VIN A A A A VIN VIN VIN B VIN
+ A B A VIN VIN B A B A B A B B VIN A VIN A B A A A A VIN B A VIN A VIN VIN VIN B
+ VIN B VIN VIN VIN A B B VIN VIN A A VIN VIN B VIN VIN B VIN B A A VIN VIN B A A
+ A A VIN A B A B A A A B VIN VIN B B A A A B B B B VIN VIN B A B VIN B B B B B B
+ B VIN A VIN VIN B A VIN B B VIN B B A B A VIN VIN VIN A VIN VIN VIN VIN B B B B
+ A A VIN A B B VIN B VIN A A VIN VIN VIN A B A VIN A B VIN A A B VIN B B VIN A B
+ VIN VIN B VIN A B VIN VIN B A VIN B B A A A A VIN VIN A A B A A VIN B A A A A B
+ A A A A A B B A A B A A A A B VIN B VIN B VIN A A VIN A B VIN VIN VIN B A B A VIN
+ B A B B VIN VIN B VIN VIN A VIN B A B B B B B A VIN B B B VIN VIN B B A B VIN B
+ A B B B A A B A A B B B VIN VIN B VIN A A A VIN VIN VIN VIN A VIN A VIN B B VIN
+ VIN VIN B B VIN A A B A A A VIN VIN A B VIN VIN B B B A A B A B VIN VIN B VIN B
+ VIN B VIN A B VIN VIN A VIN A VIN VIN A VIN B A B B VIN A VIN B VIN B A A A A A
+ A A A VIN VIN B A A B VIN VIN A A B A B B A B VIN A B B B VIN B A VIN B VIN A VIN
+ B VIN VIN A B VIN VIN A B B B A B B VIN B VIN VIN VIN B VIN VIN B B A A VIN VIN
+ VIN A A B A A B A A VIN VIN A A VIN A A VIN VIN VIN B VIN A B B A VIN VIN A VIN
+ VIN VIN VIN VIN A A VIN A B A A A VIN A B A B A A A VIN A A A A VIN VIN A B A B
+ VIN VIN A VIN VIN B B VIN VIN VIN VIN A B VIN VIN VIN B VIN B VIN VIN A A VIN B
+ A VIN VIN VIN B A VIN VIN VIN VIN VIN VIN VIN VIN VIN VIN VIN VIN A VIN B B VIN
+ VIN B VIN VIN B A VIN A A B B B B B B B B B B B VIN A B VIN A B B A B VIN B VIN
+ B B B A A A B A VIN VIN A A VIN B B B B A B A A VIN A B VIN VIN B A VIN VIN B A
+ B A A B VIN A A B VIN A VIN A VIN A VIN B B A A A A B A B VIN A A VIN B A A VIN
+ B A VIN B VIN A A VIN VIN A A VIN VIN VIN B VIN B A A B VIN B A A VIN B VIN B VIN
+ A VIN VIN A VIN B B VIN B B VIN VIN B VIN B VIN B A B B VIN B VIN B VIN B VIN B
+ B B A VIN B A B B A A A VIN A VIN B B VIN VIN B B B VIN B B A B A A A A B A A VIN
+ B A A B B A B VIN B A A A VIN B A B A VIN A B VIN B A A B A VIN VIN B B A VIN VIN
+ B VIN VIN A VIN VIN VIN VIN B VIN VIN A A A B B VIN B B VIN VIN VIN A VIN B VIN
+ A VIN VIN VIN VIN B B A VIN VIN B VIN VIN VIN B B B A A B A A B VIN A B B VIN B
+ B A B VIN A A VIN A B B B A VIN B A B VIN B A B VIN B VIN A VIN A B B B VIN B VIN
+ A VIN VIN B B B B VIN B B B A B A A A A VIN A VIN A B VIN B VIN B A B A A A A B
+ B A A A A VIN B A VIN VIN VIN B A A A B B A VIN B A VIN B VIN A VIN B A VIN A A
+ A A B A VIN VIN B A A VIN B A VIN B A VIN B VIN B B VIN VIN VIN VIN VIN A B B VIN
+ VIN VIN A A A VIN B A B A VIN VIN B B B B B B B VIN VIN VIN A A B B VIN B A A B
+ A B VIN B A VIN A VIN A B A A B A VIN B B VIN B VIN VIN A B A A VIN B VIN B A VIN
+ VIN B A B VIN VIN VIN A B A VIN VIN VIN VIN B VIN A VIN B B A A VIN VIN A A B VIN
+ A A B VIN A VIN VIN VIN VIN A B A VIN VIN VIN B B VIN A VIN A A VIN A A A A A A
+ B A A A A A A A B A VIN A VIN A B B A A VIN A B A B VIN B A A VIN B B B A VIN B
+ B B A VIN VIN B B B B B B B B VIN B VIN VIN B B A B VIN VIN B VIN VIN A B A B B
+ B B A VIN B A VIN A B B A A B B A B B B VIN B B VIN B VIN A A B VIN VIN VIN VIN
+ B VIN B A A VIN B A A VIN VIN VIN VIN VIN B A VIN VIN B A B VIN B B A A VIN VIN
+ VIN B B VIN VIN B A VIN VIN B B A B A B VIN VIN VIN A VIN B VIN VIN VIN A B A A
+ A A A A B B B A A A A A B VIN A A B B A VIN A A B B B A B A B A B B A B VIN A B
+ B B A B B B A VIN VIN A B VIN B B A VIN B B A B B A VIN B A A A B B VIN B VIN A
+ B VIN B VIN B A A VIN A VIN B VIN A B VIN A B VIN A VIN A A VIN VIN VIN A VIN A
+ A B A B VIN VIN B A B B A A A A B A A B A VIN A A A A B A VIN A B A A A A A B A
+ B A VIN VIN VIN VIN A A VIN VIN VIN B A A A B VIN B VIN A VIN VIN B A A VIN B VIN
+ B B VIN A B VIN A B VIN VIN A A B VIN A B A VIN B B B VIN B VIN B B VIN A A A B
+ A VIN B A A A VIN VIN VIN B VIN B VIN A A B B A B B B B A VIN VIN A VIN B B B VIN
+ VIN B VIN VIN VIN B A A B A VIN A VIN VIN VIN VIN B VIN A B B A B A VIN VIN A VIN
+ VIN VIN VIN A VIN VIN A A VIN VIN VIN VIN B A A A B B VIN VIN A B VIN B A B A A
+ A A A A B VIN A A VIN B A B B A B VIN B B B VIN B A A VIN VIN A VIN A B B B VIN
+ B A B A VIN VIN VIN B VIN A A VIN B B B VIN VIN B A A B A B B VIN B B A VIN B B
+ B B B A A VIN B A B VIN A VIN B A VIN VIN B B B A B B VIN B VIN A VIN A A VIN A
+ A A A VIN B VIN B VIN VIN A B A A A A A A A A VIN B A A B A B A A VIN B VIN B B
+ VIN B VIN VIN VIN VIN VIN B A VIN B VIN VIN B B A VIN B VIN A VIN B VIN VIN VIN
+ VIN VIN VIN B VIN VIN B VIN VIN B B A A VIN VIN B VIN B VIN B VIN B B VIN B VIN
+ VIN A B VIN B A B B VIN VIN B B B VIN A B B A A VIN B B VIN VIN B A A VIN B B B
+ VIN A B VIN VIN B VIN A VIN A A B B A VIN VIN VIN VIN A A A VIN VIN VIN A B VIN
+ A B VIN B A A VIN A A A A A A A A VIN A A VIN B B A A A VIN A B A B A A A A B VIN
+ A A B A A A VIN A B A VIN A VIN VIN VIN VIN A VIN B A VIN A VIN VIN VIN VIN B VIN
+ A VIN B VIN VIN B VIN VIN A A A A VIN B B VIN VIN VIN B A B B VIN B B A B B A VIN
+ A B A B VIN VIN A B B VIN B A B A A VIN A B A B VIN A B B A VIN B A A A VIN B A
+ B A A A B B A VIN B A B A VIN VIN A A B B VIN A VIN VIN VIN VIN VIN A VIN A A B
+ A B VIN B B VIN A B B B VIN VIN B B VIN VIN VIN A VIN VIN A A A VIN B VIN B A A
+ A B VIN A A B B B B A A A B B A VIN A VIN A A B VIN A B A VIN VIN B B B VIN A VIN
+ VIN VIN B A B B B B A B B A VIN B B A B B B VIN B VIN VIN A A VIN VIN VIN B A B
+ VIN A B A A VIN VIN A B VIN B A A A B VIN VIN B VIN B VIN B VIN A A A B A A B A
+ A A A A VIN VIN A B A B VIN B B B B A A A A B B VIN A VIN A VIN B A VIN A A A VIN
+ VIN A VIN B A VIN VIN VIN B B VIN A VIN VIN VIN B VIN VIN VIN A VIN VIN VIN VIN
+ VIN B A A B B A A B B A VIN B B B A B B VIN A B B B A B VIN B A A B B A VIN B B
+ A B B B B VIN VIN A A VIN A B VIN A B VIN A B B A B VIN B VIN A VIN B B A B VIN
+ A A VIN VIN B VIN B VIN VIN VIN A A B VIN B B VIN VIN B B A VIN A A VIN VIN A VIN
+ B VIN B A B VIN A VIN B A VIN VIN A A B B VIN A A B A A A B A A A B A A B A VIN
+ A VIN VIN VIN VIN A A B A B VIN A VIN A A B B VIN B VIN A VIN B B VIN B B sky130_fd_pr__pfet_01v8_E8WXEL
.ends
